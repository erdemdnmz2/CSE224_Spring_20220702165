* NGSPICE file created from top_module.ext - technology: sky130A

* Black-box entry subcircuit for sky130_fd_sc_hd__decap_3 abstract view
.subckt sky130_fd_sc_hd__decap_3 VGND VNB VPB VPWR
.ends

* Black-box entry subcircuit for sky130_fd_sc_hd__nor2_1 abstract view
.subckt sky130_fd_sc_hd__nor2_1 A B VGND VNB VPB VPWR Y
.ends

* Black-box entry subcircuit for sky130_fd_sc_hd__mux2_1 abstract view
.subckt sky130_fd_sc_hd__mux2_1 A0 A1 S VGND VNB VPB VPWR X
.ends

* Black-box entry subcircuit for sky130_fd_sc_hd__tapvpwrvgnd_1 abstract view
.subckt sky130_fd_sc_hd__tapvpwrvgnd_1 VGND VPWR
.ends

* Black-box entry subcircuit for sky130_fd_sc_hd__and2_1 abstract view
.subckt sky130_fd_sc_hd__and2_1 A B VGND VNB VPB VPWR X
.ends

* Black-box entry subcircuit for sky130_ef_sc_hd__decap_12 abstract view
.subckt sky130_ef_sc_hd__decap_12 VPWR VGND VPB VNB
.ends

* Black-box entry subcircuit for sky130_fd_sc_hd__inv_2 abstract view
.subckt sky130_fd_sc_hd__inv_2 A VGND VNB VPB VPWR Y
.ends

* Black-box entry subcircuit for sky130_fd_sc_hd__clkbuf_1 abstract view
.subckt sky130_fd_sc_hd__clkbuf_1 A VGND VNB VPB VPWR X
.ends

* Black-box entry subcircuit for sky130_fd_sc_hd__buf_1 abstract view
.subckt sky130_fd_sc_hd__buf_1 A VGND VNB VPB VPWR X
.ends

* Black-box entry subcircuit for sky130_fd_sc_hd__decap_8 abstract view
.subckt sky130_fd_sc_hd__decap_8 VGND VNB VPB VPWR
.ends

* Black-box entry subcircuit for sky130_fd_sc_hd__decap_4 abstract view
.subckt sky130_fd_sc_hd__decap_4 VGND VNB VPB VPWR
.ends

* Black-box entry subcircuit for sky130_fd_sc_hd__decap_6 abstract view
.subckt sky130_fd_sc_hd__decap_6 VGND VNB VPB VPWR
.ends

* Black-box entry subcircuit for sky130_fd_sc_hd__fill_1 abstract view
.subckt sky130_fd_sc_hd__fill_1 VGND VNB VPB VPWR
.ends

* Black-box entry subcircuit for sky130_fd_sc_hd__diode_2 abstract view
.subckt sky130_fd_sc_hd__diode_2 DIODE VGND VNB VPB VPWR
.ends

* Black-box entry subcircuit for sky130_fd_sc_hd__fill_2 abstract view
.subckt sky130_fd_sc_hd__fill_2 VGND VNB VPB VPWR
.ends

* Black-box entry subcircuit for sky130_fd_sc_hd__xnor2_1 abstract view
.subckt sky130_fd_sc_hd__xnor2_1 A B VGND VNB VPB VPWR Y
.ends

* Black-box entry subcircuit for sky130_fd_sc_hd__nand2_1 abstract view
.subckt sky130_fd_sc_hd__nand2_1 A B VGND VNB VPB VPWR Y
.ends

* Black-box entry subcircuit for sky130_fd_sc_hd__nor2_2 abstract view
.subckt sky130_fd_sc_hd__nor2_2 A B VGND VNB VPB VPWR Y
.ends

* Black-box entry subcircuit for sky130_fd_sc_hd__or2_1 abstract view
.subckt sky130_fd_sc_hd__or2_1 A B VGND VNB VPB VPWR X
.ends

* Black-box entry subcircuit for sky130_fd_sc_hd__or2_2 abstract view
.subckt sky130_fd_sc_hd__or2_2 A B VGND VNB VPB VPWR X
.ends

* Black-box entry subcircuit for sky130_fd_sc_hd__a21oi_4 abstract view
.subckt sky130_fd_sc_hd__a21oi_4 A1 A2 B1 VGND VNB VPB VPWR Y
.ends

* Black-box entry subcircuit for sky130_fd_sc_hd__nand2b_2 abstract view
.subckt sky130_fd_sc_hd__nand2b_2 A_N B VGND VNB VPB VPWR Y
.ends

* Black-box entry subcircuit for sky130_fd_sc_hd__a21boi_4 abstract view
.subckt sky130_fd_sc_hd__a21boi_4 A1 A2 B1_N VGND VNB VPB VPWR Y
.ends

* Black-box entry subcircuit for sky130_fd_sc_hd__and2b_1 abstract view
.subckt sky130_fd_sc_hd__and2b_1 A_N B VGND VNB VPB VPWR X
.ends

* Black-box entry subcircuit for sky130_fd_sc_hd__clkbuf_2 abstract view
.subckt sky130_fd_sc_hd__clkbuf_2 A VGND VNB VPB VPWR X
.ends

* Black-box entry subcircuit for sky130_fd_sc_hd__a31o_2 abstract view
.subckt sky130_fd_sc_hd__a31o_2 A1 A2 A3 B1 VGND VNB VPB VPWR X
.ends

* Black-box entry subcircuit for sky130_fd_sc_hd__a211o_2 abstract view
.subckt sky130_fd_sc_hd__a211o_2 A1 A2 B1 C1 VGND VNB VPB VPWR X
.ends

* Black-box entry subcircuit for sky130_fd_sc_hd__bufinv_16 abstract view
.subckt sky130_fd_sc_hd__bufinv_16 A VGND VNB VPB VPWR Y
.ends

* Black-box entry subcircuit for sky130_fd_sc_hd__a211o_1 abstract view
.subckt sky130_fd_sc_hd__a211o_1 A1 A2 B1 C1 VGND VNB VPB VPWR X
.ends

* Black-box entry subcircuit for sky130_fd_sc_hd__a21oi_1 abstract view
.subckt sky130_fd_sc_hd__a21oi_1 A1 A2 B1 VGND VNB VPB VPWR Y
.ends

* Black-box entry subcircuit for sky130_fd_sc_hd__a21oi_2 abstract view
.subckt sky130_fd_sc_hd__a21oi_2 A1 A2 B1 VGND VNB VPB VPWR Y
.ends

* Black-box entry subcircuit for sky130_fd_sc_hd__nand3_1 abstract view
.subckt sky130_fd_sc_hd__nand3_1 A B C VGND VNB VPB VPWR Y
.ends

* Black-box entry subcircuit for sky130_fd_sc_hd__and4b_1 abstract view
.subckt sky130_fd_sc_hd__and4b_1 A_N B C D VGND VNB VPB VPWR X
.ends

* Black-box entry subcircuit for sky130_fd_sc_hd__o21a_2 abstract view
.subckt sky130_fd_sc_hd__o21a_2 A1 A2 B1 VGND VNB VPB VPWR X
.ends

* Black-box entry subcircuit for sky130_fd_sc_hd__xnor2_2 abstract view
.subckt sky130_fd_sc_hd__xnor2_2 A B VGND VNB VPB VPWR Y
.ends

* Black-box entry subcircuit for sky130_fd_sc_hd__buf_2 abstract view
.subckt sky130_fd_sc_hd__buf_2 A VGND VNB VPB VPWR X
.ends

* Black-box entry subcircuit for sky130_fd_sc_hd__a31o_1 abstract view
.subckt sky130_fd_sc_hd__a31o_1 A1 A2 A3 B1 VGND VNB VPB VPWR X
.ends

* Black-box entry subcircuit for sky130_fd_sc_hd__a21o_1 abstract view
.subckt sky130_fd_sc_hd__a21o_1 A1 A2 B1 VGND VNB VPB VPWR X
.ends

* Black-box entry subcircuit for sky130_fd_sc_hd__o221a_1 abstract view
.subckt sky130_fd_sc_hd__o221a_1 A1 A2 B1 B2 C1 VGND VNB VPB VPWR X
.ends

* Black-box entry subcircuit for sky130_fd_sc_hd__or4b_1 abstract view
.subckt sky130_fd_sc_hd__or4b_1 A B C D_N VGND VNB VPB VPWR X
.ends

* Black-box entry subcircuit for sky130_fd_sc_hd__dfxtp_1 abstract view
.subckt sky130_fd_sc_hd__dfxtp_1 CLK D VGND VNB VPB VPWR Q
.ends

* Black-box entry subcircuit for sky130_fd_sc_hd__or2b_2 abstract view
.subckt sky130_fd_sc_hd__or2b_2 A B_N VGND VNB VPB VPWR X
.ends

* Black-box entry subcircuit for sky130_fd_sc_hd__xor2_1 abstract view
.subckt sky130_fd_sc_hd__xor2_1 A B VGND VNB VPB VPWR X
.ends

* Black-box entry subcircuit for sky130_fd_sc_hd__a2bb2o_2 abstract view
.subckt sky130_fd_sc_hd__a2bb2o_2 A1_N A2_N B1 B2 VGND VNB VPB VPWR X
.ends

* Black-box entry subcircuit for sky130_fd_sc_hd__dfrtp_1 abstract view
.subckt sky130_fd_sc_hd__dfrtp_1 CLK D RESET_B VGND VNB VPB VPWR Q
.ends

* Black-box entry subcircuit for sky130_fd_sc_hd__o21ai_2 abstract view
.subckt sky130_fd_sc_hd__o21ai_2 A1 A2 B1 VGND VNB VPB VPWR Y
.ends

* Black-box entry subcircuit for sky130_fd_sc_hd__and4bb_1 abstract view
.subckt sky130_fd_sc_hd__and4bb_1 A_N B_N C D VGND VNB VPB VPWR X
.ends

* Black-box entry subcircuit for sky130_fd_sc_hd__clkbuf_4 abstract view
.subckt sky130_fd_sc_hd__clkbuf_4 A VGND VNB VPB VPWR X
.ends

* Black-box entry subcircuit for sky130_fd_sc_hd__dfrtp_4 abstract view
.subckt sky130_fd_sc_hd__dfrtp_4 CLK D RESET_B VGND VNB VPB VPWR Q
.ends

* Black-box entry subcircuit for sky130_fd_sc_hd__a221o_1 abstract view
.subckt sky130_fd_sc_hd__a221o_1 A1 A2 B1 B2 C1 VGND VNB VPB VPWR X
.ends

* Black-box entry subcircuit for sky130_fd_sc_hd__conb_1 abstract view
.subckt sky130_fd_sc_hd__conb_1 VGND VNB VPB VPWR HI LO
.ends

* Black-box entry subcircuit for sky130_fd_sc_hd__dfrtp_2 abstract view
.subckt sky130_fd_sc_hd__dfrtp_2 CLK D RESET_B VGND VNB VPB VPWR Q
.ends

* Black-box entry subcircuit for sky130_fd_sc_hd__nor3b_2 abstract view
.subckt sky130_fd_sc_hd__nor3b_2 A B C_N VGND VNB VPB VPWR Y
.ends

* Black-box entry subcircuit for sky130_fd_sc_hd__clkbuf_16 abstract view
.subckt sky130_fd_sc_hd__clkbuf_16 A VGND VNB VPB VPWR X
.ends

* Black-box entry subcircuit for sky130_fd_sc_hd__o21a_1 abstract view
.subckt sky130_fd_sc_hd__o21a_1 A1 A2 B1 VGND VNB VPB VPWR X
.ends

* Black-box entry subcircuit for sky130_fd_sc_hd__o31ai_2 abstract view
.subckt sky130_fd_sc_hd__o31ai_2 A1 A2 A3 B1 VGND VNB VPB VPWR Y
.ends

* Black-box entry subcircuit for sky130_fd_sc_hd__dlymetal6s2s_1 abstract view
.subckt sky130_fd_sc_hd__dlymetal6s2s_1 A VGND VNB VPB VPWR X
.ends

* Black-box entry subcircuit for sky130_fd_sc_hd__a31oi_4 abstract view
.subckt sky130_fd_sc_hd__a31oi_4 A1 A2 A3 B1 VGND VNB VPB VPWR Y
.ends

* Black-box entry subcircuit for sky130_fd_sc_hd__and4_1 abstract view
.subckt sky130_fd_sc_hd__and4_1 A B C D VGND VNB VPB VPWR X
.ends

* Black-box entry subcircuit for sky130_fd_sc_hd__or2b_1 abstract view
.subckt sky130_fd_sc_hd__or2b_1 A B_N VGND VNB VPB VPWR X
.ends

* Black-box entry subcircuit for sky130_fd_sc_hd__or3_2 abstract view
.subckt sky130_fd_sc_hd__or3_2 A B C VGND VNB VPB VPWR X
.ends

* Black-box entry subcircuit for sky130_fd_sc_hd__o31ai_1 abstract view
.subckt sky130_fd_sc_hd__o31ai_1 A1 A2 A3 B1 VGND VNB VPB VPWR Y
.ends

* Black-box entry subcircuit for sky130_fd_sc_hd__and3_1 abstract view
.subckt sky130_fd_sc_hd__and3_1 A B C VGND VNB VPB VPWR X
.ends

* Black-box entry subcircuit for sky130_fd_sc_hd__o211ai_1 abstract view
.subckt sky130_fd_sc_hd__o211ai_1 A1 A2 B1 C1 VGND VNB VPB VPWR Y
.ends

* Black-box entry subcircuit for sky130_fd_sc_hd__o31a_1 abstract view
.subckt sky130_fd_sc_hd__o31a_1 A1 A2 A3 B1 VGND VNB VPB VPWR X
.ends

* Black-box entry subcircuit for sky130_fd_sc_hd__mux2_2 abstract view
.subckt sky130_fd_sc_hd__mux2_2 A0 A1 S VGND VNB VPB VPWR X
.ends

* Black-box entry subcircuit for sky130_fd_sc_hd__o21ai_1 abstract view
.subckt sky130_fd_sc_hd__o21ai_1 A1 A2 B1 VGND VNB VPB VPWR Y
.ends

* Black-box entry subcircuit for sky130_fd_sc_hd__nand2_2 abstract view
.subckt sky130_fd_sc_hd__nand2_2 A B VGND VNB VPB VPWR Y
.ends

* Black-box entry subcircuit for sky130_fd_sc_hd__a32o_4 abstract view
.subckt sky130_fd_sc_hd__a32o_4 A1 A2 A3 B1 B2 VGND VNB VPB VPWR X
.ends

* Black-box entry subcircuit for sky130_fd_sc_hd__and3b_1 abstract view
.subckt sky130_fd_sc_hd__and3b_1 A_N B C VGND VNB VPB VPWR X
.ends

* Black-box entry subcircuit for sky130_fd_sc_hd__a2bb2o_4 abstract view
.subckt sky130_fd_sc_hd__a2bb2o_4 A1_N A2_N B1 B2 VGND VNB VPB VPWR X
.ends

* Black-box entry subcircuit for sky130_fd_sc_hd__nand3b_4 abstract view
.subckt sky130_fd_sc_hd__nand3b_4 A_N B C VGND VNB VPB VPWR Y
.ends

* Black-box entry subcircuit for sky130_fd_sc_hd__a22o_4 abstract view
.subckt sky130_fd_sc_hd__a22o_4 A1 A2 B1 B2 VGND VNB VPB VPWR X
.ends

* Black-box entry subcircuit for sky130_fd_sc_hd__and3_2 abstract view
.subckt sky130_fd_sc_hd__and3_2 A B C VGND VNB VPB VPWR X
.ends

.subckt top_module BTNR BTNU CLK100MHZ VGND VPWR an[0] an[1] an[2] an[3] seg[0] seg[1]
+ seg[2] seg[3] seg[4] seg[5] seg[6]
XFILLER_0_7_92 VGND VGND VPWR VPWR sky130_fd_sc_hd__decap_3
X_294_ rf.regs\[5\]\[4\] _105_ VGND VGND VPWR VPWR _136_ sky130_fd_sc_hd__nor2_1
X_432_ rf.regs\[5\]\[4\] _213_ _054_ VGND VGND VPWR VPWR _059_ sky130_fd_sc_hd__mux2_1
XTAP_TAPCELL_ROW_15_106 VGND VPWR sky130_fd_sc_hd__tapvpwrvgnd_1
X_363_ net2 _197_ VGND VGND VPWR VPWR _198_ sky130_fd_sc_hd__and2_1
XTAP_TAPCELL_ROW_20_120 VGND VPWR sky130_fd_sc_hd__tapvpwrvgnd_1
XFILLER_0_18_29 VPWR VGND VPWR VGND sky130_ef_sc_hd__decap_12
X_346_ _174_ VGND VGND VPWR VPWR _187_ sky130_fd_sc_hd__inv_2
X_415_ _049_ VGND VGND VPWR VPWR _019_ sky130_fd_sc_hd__clkbuf_1
X_277_ _118_ VGND VGND VPWR VPWR _119_ sky130_fd_sc_hd__buf_1
XFILLER_0_24_72 VPWR VGND VPWR VGND sky130_ef_sc_hd__decap_12
XFILLER_0_20_19 VGND VGND VPWR VPWR sky130_fd_sc_hd__decap_8
X_329_ _144_ VGND VGND VPWR VPWR _171_ sky130_fd_sc_hd__inv_2
XFILLER_0_0_29 VGND VGND VPWR VPWR sky130_fd_sc_hd__decap_4
XFILLER_0_9_49 VGND VGND VPWR VPWR sky130_fd_sc_hd__decap_6
XFILLER_0_10_41 VGND VGND VPWR VPWR sky130_fd_sc_hd__decap_3
XFILLER_0_10_85 VPWR VGND VPWR VGND sky130_ef_sc_hd__decap_12
XFILLER_0_19_169 VGND VGND VPWR VPWR sky130_fd_sc_hd__decap_8
XPHY_EDGE_ROW_8_Left_36 VGND VGND VPWR VPWR sky130_fd_sc_hd__decap_3
XFILLER_0_21_84 VGND VGND VPWR VPWR sky130_fd_sc_hd__fill_1
XFILLER_0_16_117 VGND VGND VPWR VPWR sky130_fd_sc_hd__fill_1
XFILLER_0_26_29 VGND VGND VPWR VPWR sky130_fd_sc_hd__fill_1
XANTENNA_5 rf.regs\[10\]\[0\] VGND VGND VPWR VPWR sky130_fd_sc_hd__diode_2
XFILLER_0_21_120 VPWR VGND VPWR VGND sky130_ef_sc_hd__decap_12
XFILLER_0_6_39 VGND VGND VPWR VPWR sky130_fd_sc_hd__decap_6
XFILLER_0_8_136 VGND VGND VPWR VPWR sky130_fd_sc_hd__decap_4
XFILLER_0_8_147 VGND VGND VPWR VPWR sky130_fd_sc_hd__fill_2
XFILLER_0_8_158 VGND VGND VPWR VPWR sky130_fd_sc_hd__decap_4
XTAP_TAPCELL_ROW_18_115 VGND VPWR sky130_fd_sc_hd__tapvpwrvgnd_1
Xoutput7 net7 VGND VGND VPWR VPWR seg[4] sky130_fd_sc_hd__buf_1
XFILLER_0_27_94 VPWR VGND VPWR VGND sky130_ef_sc_hd__decap_12
XFILLER_0_23_19 VPWR VGND VPWR VGND sky130_ef_sc_hd__decap_12
XPHY_EDGE_ROW_21_Left_49 VGND VGND VPWR VPWR sky130_fd_sc_hd__decap_3
XFILLER_0_3_18 VPWR VGND VPWR VGND sky130_ef_sc_hd__decap_12
X_293_ _134_ VGND VGND VPWR VPWR _135_ sky130_fd_sc_hd__buf_1
X_431_ _058_ VGND VGND VPWR VPWR _026_ sky130_fd_sc_hd__buf_1
X_362_ _196_ VGND VGND VPWR VPWR _197_ sky130_fd_sc_hd__clkbuf_1
XFILLER_0_1_175 VGND VGND VPWR VPWR sky130_fd_sc_hd__fill_2
XTAP_TAPCELL_ROW_20_121 VGND VPWR sky130_fd_sc_hd__tapvpwrvgnd_1
XFILLER_0_18_19 VGND VGND VPWR VPWR sky130_fd_sc_hd__fill_1
X_345_ _158_ _186_ VGND VGND VPWR VPWR net3 sky130_fd_sc_hd__xnor2_1
X_414_ rf.regs\[0\]\[1\] _047_ VGND VGND VPWR VPWR _049_ sky130_fd_sc_hd__and2_1
X_276_ _091_ VGND VGND VPWR VPWR _118_ sky130_fd_sc_hd__buf_1
XPHY_EDGE_ROW_21_Right_21 VGND VGND VPWR VPWR sky130_fd_sc_hd__decap_3
XPHY_EDGE_ROW_12_Right_12 VGND VGND VPWR VPWR sky130_fd_sc_hd__decap_3
X_328_ _161_ _168_ VGND VGND VPWR VPWR _170_ sky130_fd_sc_hd__nand2_1
X_259_ _060_ _065_ VGND VGND VPWR VPWR _101_ sky130_fd_sc_hd__nor2_2
XFILLER_0_9_39 VGND VGND VPWR VPWR sky130_fd_sc_hd__fill_1
XFILLER_0_27_181 VGND VGND VPWR VPWR sky130_fd_sc_hd__decap_6
XPHY_EDGE_ROW_24_Left_52 VGND VGND VPWR VPWR sky130_fd_sc_hd__decap_3
XFILLER_0_10_97 VGND VGND VPWR VPWR sky130_fd_sc_hd__fill_1
XFILLER_0_27_3 VPWR VGND VPWR VGND sky130_ef_sc_hd__decap_12
XFILLER_0_26_19 VGND VGND VPWR VPWR sky130_fd_sc_hd__decap_8
XANTENNA_6 _150_ VGND VGND VPWR VPWR sky130_fd_sc_hd__diode_2
XFILLER_0_21_132 VPWR VGND VPWR VGND sky130_ef_sc_hd__decap_12
XFILLER_0_16_85 VGND VGND VPWR VPWR sky130_fd_sc_hd__decap_6
XFILLER_0_16_41 VGND VGND VPWR VPWR sky130_fd_sc_hd__decap_3
XFILLER_0_12_154 VPWR VGND VPWR VGND sky130_ef_sc_hd__decap_12
XFILLER_0_12_132 VGND VGND VPWR VPWR sky130_fd_sc_hd__decap_8
XPHY_EDGE_ROW_6_Right_6 VGND VGND VPWR VPWR sky130_fd_sc_hd__decap_3
Xoutput8 net8 VGND VGND VPWR VPWR seg[5] sky130_fd_sc_hd__buf_1
XTAP_TAPCELL_ROW_23_130 VGND VPWR sky130_fd_sc_hd__tapvpwrvgnd_1
X_430_ rf.regs\[5\]\[3\] _174_ _054_ VGND VGND VPWR VPWR _058_ sky130_fd_sc_hd__mux2_1
X_292_ _133_ VGND VGND VPWR VPWR _134_ sky130_fd_sc_hd__buf_1
XFILLER_0_7_50 VGND VGND VPWR VPWR sky130_fd_sc_hd__decap_6
X_361_ _073_ VGND VGND VPWR VPWR _196_ sky130_fd_sc_hd__clkbuf_1
XFILLER_0_1_187 VGND VGND VPWR VPWR sky130_fd_sc_hd__decap_3
X_344_ _174_ _185_ VGND VGND VPWR VPWR _186_ sky130_fd_sc_hd__nor2_1
X_413_ _048_ VGND VGND VPWR VPWR _018_ sky130_fd_sc_hd__clkbuf_1
X_275_ _083_ VGND VGND VPWR VPWR _117_ sky130_fd_sc_hd__buf_1
XFILLER_0_24_85 VPWR VGND VPWR VGND sky130_ef_sc_hd__decap_12
XFILLER_0_24_41 VGND VGND VPWR VPWR sky130_fd_sc_hd__fill_2
XFILLER_0_19_105 VGND VGND VPWR VPWR sky130_fd_sc_hd__decap_6
X_327_ _161_ _168_ VGND VGND VPWR VPWR _169_ sky130_fd_sc_hd__or2_1
X_258_ rf.regs\[15\]\[1\] _099_ VGND VGND VPWR VPWR _100_ sky130_fd_sc_hd__or2_2
XFILLER_0_18_160 VGND VGND VPWR VPWR sky130_fd_sc_hd__decap_3
XFILLER_0_24_152 VGND VGND VPWR VPWR sky130_fd_sc_hd__decap_6
XFILLER_0_24_141 VGND VGND VPWR VPWR sky130_fd_sc_hd__decap_8
XFILLER_0_21_53 VGND VGND VPWR VPWR sky130_fd_sc_hd__decap_3
XFILLER_0_21_166 VGND VGND VPWR VPWR sky130_fd_sc_hd__fill_2
XFILLER_0_21_144 VPWR VGND VPWR VGND sky130_ef_sc_hd__decap_12
XFILLER_0_6_19 VGND VGND VPWR VPWR sky130_fd_sc_hd__fill_2
XFILLER_0_12_166 VPWR VGND VPWR VGND sky130_ef_sc_hd__decap_12
Xoutput9 net9 VGND VGND VPWR VPWR seg[6] sky130_fd_sc_hd__buf_1
XFILLER_0_27_85 VGND VGND VPWR VPWR sky130_fd_sc_hd__decap_3
X_291_ _130_ _131_ _132_ VGND VGND VPWR VPWR _133_ sky130_fd_sc_hd__a21oi_4
XFILLER_0_4_141 VPWR VGND VPWR VGND sky130_ef_sc_hd__decap_12
X_360_ _189_ _195_ VGND VGND VPWR VPWR net9 sky130_fd_sc_hd__nand2_1
XFILLER_0_1_111 VGND VGND VPWR VPWR sky130_fd_sc_hd__fill_1
X_412_ rf.regs\[0\]\[0\] _047_ VGND VGND VPWR VPWR _048_ sky130_fd_sc_hd__and2_1
X_274_ _115_ VGND VGND VPWR VPWR _116_ sky130_fd_sc_hd__buf_1
X_343_ _138_ _184_ VGND VGND VPWR VPWR _185_ sky130_fd_sc_hd__nor2_1
XFILLER_0_24_97 VGND VGND VPWR VPWR sky130_fd_sc_hd__decap_6
XFILLER_0_4_41 VPWR VGND VPWR VGND sky130_ef_sc_hd__decap_12
XFILLER_0_4_85 VPWR VGND VPWR VGND sky130_ef_sc_hd__decap_12
X_257_ imem.address\[2\] imem.address\[1\] VGND VGND VPWR VPWR _099_ sky130_fd_sc_hd__nand2b_2
X_326_ _166_ _167_ VGND VGND VPWR VPWR _168_ sky130_fd_sc_hd__nor2_2
XFILLER_0_9_19 VPWR VGND VPWR VGND sky130_ef_sc_hd__decap_12
XFILLER_0_24_120 VPWR VGND VPWR VGND sky130_ef_sc_hd__decap_12
X_309_ _149_ _133_ _150_ VGND VGND VPWR VPWR _151_ sky130_fd_sc_hd__a21boi_4
XFILLER_0_1_42 VGND VGND VPWR VPWR sky130_fd_sc_hd__fill_1
XFILLER_0_21_189 VGND VGND VPWR VPWR sky130_fd_sc_hd__fill_1
XFILLER_0_21_156 VGND VGND VPWR VPWR sky130_fd_sc_hd__decap_8
XTAP_TAPCELL_ROW_10_90 VGND VPWR sky130_fd_sc_hd__tapvpwrvgnd_1
XFILLER_0_16_65 VGND VGND VPWR VPWR sky130_fd_sc_hd__decap_3
XFILLER_0_12_178 VGND VGND VPWR VPWR sky130_fd_sc_hd__decap_4
XFILLER_0_7_161 VGND VGND VPWR VPWR sky130_fd_sc_hd__decap_6
XFILLER_0_5_109 VGND VGND VPWR VPWR sky130_fd_sc_hd__decap_3
XFILLER_0_4_153 VPWR VGND VPWR VGND sky130_ef_sc_hd__decap_12
XFILLER_0_13_44 VGND VGND VPWR VPWR sky130_fd_sc_hd__fill_1
X_290_ _061_ _066_ VGND VGND VPWR VPWR _132_ sky130_fd_sc_hd__and2b_1
XFILLER_0_13_77 VGND VGND VPWR VPWR sky130_fd_sc_hd__decap_4
XFILLER_0_1_145 VGND VGND VPWR VPWR sky130_fd_sc_hd__fill_2
XTAP_TAPCELL_ROW_3_70 VGND VPWR sky130_fd_sc_hd__tapvpwrvgnd_1
X_273_ _103_ VGND VGND VPWR VPWR _115_ sky130_fd_sc_hd__clkbuf_1
X_411_ _046_ VGND VGND VPWR VPWR _047_ sky130_fd_sc_hd__clkbuf_2
X_342_ _095_ _179_ _181_ _183_ VGND VGND VPWR VPWR _184_ sky130_fd_sc_hd__a31o_2
XFILLER_0_4_53 VGND VGND VPWR VPWR sky130_fd_sc_hd__fill_2
XFILLER_0_4_97 VGND VGND VPWR VPWR sky130_fd_sc_hd__decap_8
X_325_ _163_ _165_ VGND VGND VPWR VPWR _167_ sky130_fd_sc_hd__nor2_1
XTAP_TAPCELL_ROW_0_60 VGND VPWR sky130_fd_sc_hd__tapvpwrvgnd_1
X_256_ rf.regs\[0\]\[1\] _071_ _072_ _097_ VGND VGND VPWR VPWR _098_ sky130_fd_sc_hd__a211o_2
XFILLER_0_10_67 VPWR VGND VPWR VGND sky130_ef_sc_hd__decap_12
Xclkload0 clknet_1_1__leaf_CLK100MHZ VGND VGND VPWR VPWR clkload0/Y sky130_fd_sc_hd__bufinv_16
XFILLER_0_24_165 VPWR VGND VPWR VGND sky130_ef_sc_hd__decap_12
XFILLER_0_24_132 VGND VGND VPWR VPWR sky130_fd_sc_hd__decap_8
X_239_ _075_ _076_ _079_ _080_ VGND VGND VPWR VPWR _081_ sky130_fd_sc_hd__a31o_2
XFILLER_0_21_88 VGND VGND VPWR VPWR sky130_fd_sc_hd__decap_4
XFILLER_0_21_33 VPWR VGND VPWR VGND sky130_ef_sc_hd__decap_12
X_308_ _081_ _103_ _133_ _089_ VGND VGND VPWR VPWR _150_ sky130_fd_sc_hd__a211o_1
XFILLER_0_15_187 VGND VGND VPWR VPWR sky130_fd_sc_hd__decap_3
XFILLER_0_15_132 VPWR VGND VPWR VGND sky130_ef_sc_hd__decap_12
XTAP_TAPCELL_ROW_10_91 VGND VPWR sky130_fd_sc_hd__tapvpwrvgnd_1
XFILLER_0_8_107 VPWR VGND VPWR VGND sky130_ef_sc_hd__decap_12
XFILLER_0_25_3 VGND VGND VPWR VPWR sky130_fd_sc_hd__decap_4
XPHY_EDGE_ROW_19_Right_19 VGND VGND VPWR VPWR sky130_fd_sc_hd__decap_3
XPHY_EDGE_ROW_15_Left_43 VGND VGND VPWR VPWR sky130_fd_sc_hd__decap_3
XFILLER_0_4_165 VPWR VGND VPWR VGND sky130_ef_sc_hd__decap_12
XFILLER_0_1_179 VGND VGND VPWR VPWR sky130_fd_sc_hd__fill_2
X_341_ _153_ _146_ _182_ VGND VGND VPWR VPWR _183_ sky130_fd_sc_hd__a21oi_1
X_272_ _096_ _111_ _113_ VGND VGND VPWR VPWR _114_ sky130_fd_sc_hd__a21oi_2
X_410_ _064_ net2 _065_ VGND VGND VPWR VPWR _046_ sky130_fd_sc_hd__nand3_1
XPHY_EDGE_ROW_0_Left_28 VGND VGND VPWR VPWR sky130_fd_sc_hd__decap_3
XFILLER_0_4_21 VGND VGND VPWR VPWR sky130_fd_sc_hd__decap_6
X_324_ _163_ _165_ VGND VGND VPWR VPWR _166_ sky130_fd_sc_hd__and2_1
X_255_ imem.address\[1\] imem.address\[0\] rf.regs\[5\]\[1\] _060_ VGND VGND VPWR
+ VPWR _097_ sky130_fd_sc_hd__and4b_1
XFILLER_0_10_13 VPWR VGND VPWR VGND sky130_ef_sc_hd__decap_12
XFILLER_0_10_79 VGND VGND VPWR VPWR sky130_fd_sc_hd__decap_4
XFILLER_0_27_141 VGND VGND VPWR VPWR sky130_fd_sc_hd__decap_4
XFILLER_0_19_88 VGND VGND VPWR VPWR sky130_fd_sc_hd__fill_1
XFILLER_0_19_55 VGND VGND VPWR VPWR sky130_fd_sc_hd__fill_1
XTAP_TAPCELL_ROW_0_61 VGND VPWR sky130_fd_sc_hd__tapvpwrvgnd_1
XFILLER_0_18_141 VPWR VGND VPWR VGND sky130_ef_sc_hd__decap_12
XPHY_EDGE_ROW_3_Left_31 VGND VGND VPWR VPWR sky130_fd_sc_hd__decap_3
XFILLER_0_24_177 VPWR VGND VPWR VGND sky130_ef_sc_hd__decap_12
XFILLER_0_21_45 VGND VGND VPWR VPWR sky130_fd_sc_hd__decap_8
X_238_ _065_ _066_ VGND VGND VPWR VPWR _080_ sky130_fd_sc_hd__nor2_1
X_307_ _082_ _103_ VGND VGND VPWR VPWR _149_ sky130_fd_sc_hd__and2_1
XFILLER_0_15_144 VGND VGND VPWR VPWR sky130_fd_sc_hd__fill_1
XFILLER_0_15_100 VGND VGND VPWR VPWR sky130_fd_sc_hd__decap_6
XFILLER_0_21_169 VGND VGND VPWR VPWR sky130_fd_sc_hd__fill_1
XFILLER_0_8_119 VPWR VGND VPWR VGND sky130_ef_sc_hd__decap_12
XFILLER_0_20_180 VGND VGND VPWR VPWR sky130_fd_sc_hd__decap_6
XFILLER_0_18_3 VPWR VGND VPWR VGND sky130_ef_sc_hd__decap_12
XFILLER_0_12_103 VGND VGND VPWR VPWR sky130_fd_sc_hd__fill_2
XFILLER_0_4_177 VPWR VGND VPWR VGND sky130_ef_sc_hd__decap_12
XFILLER_0_7_3 VGND VGND VPWR VPWR sky130_fd_sc_hd__decap_6
XFILLER_0_13_57 VPWR VGND VPWR VGND sky130_ef_sc_hd__decap_12
XTAP_TAPCELL_ROW_14_101 VGND VPWR sky130_fd_sc_hd__tapvpwrvgnd_1
XFILLER_0_1_169 VGND VGND VPWR VPWR sky130_fd_sc_hd__decap_3
XFILLER_0_1_125 VGND VGND VPWR VPWR sky130_fd_sc_hd__decap_4
X_340_ _113_ VGND VGND VPWR VPWR _182_ sky130_fd_sc_hd__clkbuf_1
X_271_ _065_ _067_ _064_ VGND VGND VPWR VPWR _113_ sky130_fd_sc_hd__o21a_2
X_323_ _128_ _164_ VGND VGND VPWR VPWR _165_ sky130_fd_sc_hd__xnor2_2
X_254_ _084_ _095_ VGND VGND VPWR VPWR _096_ sky130_fd_sc_hd__nor2_2
XFILLER_0_10_25 VGND VGND VPWR VPWR sky130_fd_sc_hd__decap_3
XFILLER_0_27_153 VPWR VGND VPWR VGND sky130_ef_sc_hd__decap_12
XFILLER_0_19_34 VPWR VGND VPWR VGND sky130_ef_sc_hd__decap_12
XFILLER_0_18_153 VGND VGND VPWR VPWR sky130_fd_sc_hd__decap_3
XFILLER_0_24_189 VGND VGND VPWR VPWR sky130_fd_sc_hd__fill_1
XFILLER_0_21_57 VGND VGND VPWR VPWR sky130_fd_sc_hd__fill_2
X_306_ _145_ _146_ _147_ VGND VGND VPWR VPWR _148_ sky130_fd_sc_hd__mux2_1
X_237_ rf.regs\[15\]\[0\] _078_ VGND VGND VPWR VPWR _079_ sky130_fd_sc_hd__nand2_1
XFILLER_0_15_156 VGND VGND VPWR VPWR sky130_fd_sc_hd__decap_3
XFILLER_0_1_89 VGND VGND VPWR VPWR sky130_fd_sc_hd__decap_3
XPHY_EDGE_ROW_1_Right_1 VGND VGND VPWR VPWR sky130_fd_sc_hd__decap_3
XFILLER_0_7_175 VPWR VGND VPWR VGND sky130_ef_sc_hd__decap_12
XTAP_TAPCELL_ROW_17_110 VGND VPWR sky130_fd_sc_hd__tapvpwrvgnd_1
XFILLER_0_4_189 VGND VGND VPWR VPWR sky130_fd_sc_hd__fill_1
XTAP_TAPCELL_ROW_14_102 VGND VPWR sky130_fd_sc_hd__tapvpwrvgnd_1
XFILLER_0_13_69 VGND VGND VPWR VPWR sky130_fd_sc_hd__decap_3
XFILLER_0_13_14 VPWR VGND VPWR VGND sky130_ef_sc_hd__decap_12
X_270_ _096_ _111_ VGND VGND VPWR VPWR _112_ sky130_fd_sc_hd__or2_1
X_399_ _039_ VGND VGND VPWR VPWR _040_ sky130_fd_sc_hd__buf_2
X_322_ _081_ _103_ _133_ _089_ VGND VGND VPWR VPWR _164_ sky130_fd_sc_hd__a31o_1
XFILLER_0_27_165 VGND VGND VPWR VPWR sky130_fd_sc_hd__decap_3
XFILLER_0_19_57 VGND VGND VPWR VPWR sky130_fd_sc_hd__decap_3
XFILLER_0_19_46 VGND VGND VPWR VPWR sky130_fd_sc_hd__decap_6
X_253_ rf.regs\[25\]\[0\] _091_ _094_ VGND VGND VPWR VPWR _095_ sky130_fd_sc_hd__a21o_1
XFILLER_0_10_59 VGND VGND VPWR VPWR sky130_fd_sc_hd__fill_2
X_236_ _077_ VGND VGND VPWR VPWR _078_ sky130_fd_sc_hd__clkbuf_2
X_305_ _076_ _098_ _100_ _102_ VGND VGND VPWR VPWR _147_ sky130_fd_sc_hd__a31o_1
XFILLER_0_15_113 VGND VGND VPWR VPWR sky130_fd_sc_hd__decap_3
XFILLER_0_11_91 VPWR VGND VPWR VGND sky130_ef_sc_hd__decap_12
XFILLER_0_1_57 VPWR VGND VPWR VGND sky130_ef_sc_hd__decap_12
XFILLER_0_1_35 VGND VGND VPWR VPWR sky130_fd_sc_hd__fill_2
X_219_ _063_ VGND VGND VPWR VPWR _064_ sky130_fd_sc_hd__buf_2
XFILLER_0_27_57 VPWR VGND VPWR VGND sky130_ef_sc_hd__decap_12
XTAP_TAPCELL_ROW_17_111 VGND VPWR sky130_fd_sc_hd__tapvpwrvgnd_1
XPHY_EDGE_ROW_24_Right_24 VGND VGND VPWR VPWR sky130_fd_sc_hd__decap_3
XPHY_EDGE_ROW_15_Right_15 VGND VGND VPWR VPWR sky130_fd_sc_hd__decap_3
XTAP_TAPCELL_ROW_14_103 VGND VPWR sky130_fd_sc_hd__tapvpwrvgnd_1
XFILLER_0_13_26 VPWR VGND VPWR VGND sky130_ef_sc_hd__decap_12
XFILLER_0_13_48 VGND VGND VPWR VPWR sky130_fd_sc_hd__decap_8
XPHY_EDGE_ROW_19_Left_47 VGND VGND VPWR VPWR sky130_fd_sc_hd__decap_3
X_398_ _038_ VGND VGND VPWR VPWR _039_ sky130_fd_sc_hd__clkbuf_1
XFILLER_0_14_80 VGND VGND VPWR VPWR sky130_fd_sc_hd__decap_4
X_252_ rf.regs\[0\]\[0\] _078_ _092_ rf.regs\[10\]\[0\] _093_ VGND VGND VPWR VPWR
+ _094_ sky130_fd_sc_hd__o221a_1
X_321_ rf.regs\[25\]\[3\] _162_ _093_ VGND VGND VPWR VPWR _163_ sky130_fd_sc_hd__mux2_1
XFILLER_0_24_103 VGND VGND VPWR VPWR sky130_fd_sc_hd__fill_1
XFILLER_0_21_15 VGND VGND VPWR VPWR sky130_fd_sc_hd__fill_2
X_235_ _060_ imem.address\[1\] VGND VGND VPWR VPWR _077_ sky130_fd_sc_hd__and2b_1
X_304_ _117_ _095_ VGND VGND VPWR VPWR _146_ sky130_fd_sc_hd__nand2_1
XFILLER_0_15_169 VGND VGND VPWR VPWR sky130_fd_sc_hd__fill_2
XFILLER_0_1_69 VPWR VGND VPWR VGND sky130_ef_sc_hd__decap_12
XPHY_EDGE_ROW_7_Left_35 VGND VGND VPWR VPWR sky130_fd_sc_hd__decap_3
XFILLER_0_16_15 VPWR VGND VPWR VGND sky130_ef_sc_hd__decap_12
X_218_ _062_ VGND VGND VPWR VPWR _063_ sky130_fd_sc_hd__buf_1
XFILLER_0_27_69 VPWR VGND VPWR VGND sky130_ef_sc_hd__decap_12
XFILLER_0_27_36 VPWR VGND VPWR VGND sky130_ef_sc_hd__decap_12
XTAP_TAPCELL_ROW_17_112 VGND VPWR sky130_fd_sc_hd__tapvpwrvgnd_1
XFILLER_0_7_57 VGND VGND VPWR VPWR sky130_fd_sc_hd__decap_4
XFILLER_0_7_68 VPWR VGND VPWR VGND sky130_ef_sc_hd__decap_12
XFILLER_0_13_38 VGND VGND VPWR VPWR sky130_fd_sc_hd__decap_6
XFILLER_0_24_48 VPWR VGND VPWR VGND sky130_ef_sc_hd__decap_12
XFILLER_0_24_26 VGND VGND VPWR VPWR sky130_fd_sc_hd__fill_2
XPHY_EDGE_ROW_20_Left_48 VGND VGND VPWR VPWR sky130_fd_sc_hd__decap_3
X_397_ _064_ _065_ _067_ net2 VGND VGND VPWR VPWR _038_ sky130_fd_sc_hd__or4b_1
XFILLER_0_5_3 VGND VGND VPWR VPWR sky130_fd_sc_hd__decap_8
XFILLER_0_4_69 VPWR VGND VPWR VGND sky130_ef_sc_hd__decap_12
X_251_ _087_ _089_ VGND VGND VPWR VPWR _093_ sky130_fd_sc_hd__nor2_2
XFILLER_0_19_15 VPWR VGND VPWR VGND sky130_ef_sc_hd__decap_12
X_320_ rf.regs\[0\]\[3\] rf.regs\[10\]\[3\] _106_ VGND VGND VPWR VPWR _162_ sky130_fd_sc_hd__mux2_1
XFILLER_0_27_145 VGND VGND VPWR VPWR sky130_fd_sc_hd__fill_1
X_449_ clknet_1_0__leaf_CLK100MHZ _015_ VGND VGND VPWR VPWR rf.regs\[10\]\[2\] sky130_fd_sc_hd__dfxtp_1
X_234_ _061_ _066_ VGND VGND VPWR VPWR _076_ sky130_fd_sc_hd__or2b_2
XPHY_EDGE_ROW_23_Left_51 VGND VGND VPWR VPWR sky130_fd_sc_hd__decap_3
X_303_ _121_ _144_ _084_ VGND VGND VPWR VPWR _145_ sky130_fd_sc_hd__mux2_1
XFILLER_0_1_48 VGND VGND VPWR VPWR sky130_fd_sc_hd__decap_8
XFILLER_0_1_15 VPWR VGND VPWR VGND sky130_ef_sc_hd__decap_12
XFILLER_0_15_148 VGND VGND VPWR VPWR sky130_fd_sc_hd__decap_8
XFILLER_0_16_27 VGND VGND VPWR VPWR sky130_fd_sc_hd__fill_1
X_217_ _061_ VGND VGND VPWR VPWR _062_ sky130_fd_sc_hd__clkbuf_1
XFILLER_0_7_167 VGND VGND VPWR VPWR sky130_fd_sc_hd__fill_1
XFILLER_0_27_15 VPWR VGND VPWR VGND sky130_ef_sc_hd__decap_12
XFILLER_0_27_48 VGND VGND VPWR VPWR sky130_fd_sc_hd__decap_8
XFILLER_0_4_126 VPWR VGND VPWR VGND sky130_ef_sc_hd__decap_12
XFILLER_0_17_81 VGND VGND VPWR VPWR sky130_fd_sc_hd__decap_8
XPHY_EDGE_ROW_5_Right_5 VGND VGND VPWR VPWR sky130_fd_sc_hd__decap_3
XTAP_TAPCELL_ROW_20_119 VGND VPWR sky130_fd_sc_hd__tapvpwrvgnd_1
XFILLER_0_0_184 VGND VGND VPWR VPWR sky130_fd_sc_hd__decap_3
X_396_ _037_ VGND VGND VPWR VPWR _012_ sky130_fd_sc_hd__clkbuf_1
XFILLER_0_4_15 VGND VGND VPWR VPWR sky130_fd_sc_hd__decap_3
XFILLER_0_19_27 VGND VGND VPWR VPWR sky130_fd_sc_hd__decap_4
X_250_ _087_ _078_ VGND VGND VPWR VPWR _092_ sky130_fd_sc_hd__nor2_2
XFILLER_0_27_113 VPWR VGND VPWR VGND sky130_ef_sc_hd__decap_12
X_448_ clknet_1_0__leaf_CLK100MHZ _014_ VGND VGND VPWR VPWR rf.regs\[10\]\[1\] sky130_fd_sc_hd__dfxtp_1
X_379_ _206_ _209_ VGND VGND VPWR VPWR _210_ sky130_fd_sc_hd__xor2_1
XTAP_TAPCELL_ROW_9_86 VGND VPWR sky130_fd_sc_hd__tapvpwrvgnd_1
XFILLER_0_25_81 VPWR VGND VPWR VGND sky130_ef_sc_hd__decap_12
XFILLER_0_18_179 VGND VGND VPWR VPWR sky130_fd_sc_hd__fill_1
X_233_ _070_ _071_ _073_ _074_ VGND VGND VPWR VPWR _075_ sky130_fd_sc_hd__a211o_1
X_302_ rf.regs\[25\]\[2\] _093_ _142_ _143_ VGND VGND VPWR VPWR _144_ sky130_fd_sc_hd__a2bb2o_2
XFILLER_0_1_27 VGND VGND VPWR VPWR sky130_fd_sc_hd__decap_8
XFILLER_0_23_160 VGND VGND VPWR VPWR sky130_fd_sc_hd__decap_8
XFILLER_0_11_50 VGND VGND VPWR VPWR sky130_fd_sc_hd__fill_1
XFILLER_0_7_113 VPWR VGND VPWR VGND sky130_ef_sc_hd__decap_12
X_216_ _060_ VGND VGND VPWR VPWR _061_ sky130_fd_sc_hd__clkbuf_2
XFILLER_0_27_27 VGND VGND VPWR VPWR sky130_fd_sc_hd__fill_1
XFILLER_0_4_105 VGND VGND VPWR VPWR sky130_fd_sc_hd__fill_2
XFILLER_0_4_138 VGND VGND VPWR VPWR sky130_fd_sc_hd__fill_2
XTAP_TAPCELL_ROW_23_128 VGND VPWR sky130_fd_sc_hd__tapvpwrvgnd_1
XPHY_EDGE_ROW_20_Right_20 VGND VGND VPWR VPWR sky130_fd_sc_hd__decap_3
XPHY_EDGE_ROW_11_Right_11 VGND VGND VPWR VPWR sky130_fd_sc_hd__decap_3
XFILLER_0_21_3 VPWR VGND VPWR VGND sky130_ef_sc_hd__decap_12
XFILLER_0_0_152 VPWR VGND VPWR VGND sky130_ef_sc_hd__decap_12
XFILLER_0_0_141 VGND VGND VPWR VPWR sky130_fd_sc_hd__decap_6
X_464_ clknet_1_0__leaf_CLK100MHZ _030_ _002_ VGND VGND VPWR VPWR imem.address\[2\]
+ sky130_fd_sc_hd__dfrtp_1
X_395_ rf.regs\[15\]\[4\] _213_ _032_ VGND VGND VPWR VPWR _037_ sky130_fd_sc_hd__mux2_1
XFILLER_0_4_27 VGND VGND VPWR VPWR sky130_fd_sc_hd__fill_1
XFILLER_0_27_169 VPWR VGND VPWR VGND sky130_ef_sc_hd__decap_12
XFILLER_0_27_125 VPWR VGND VPWR VGND sky130_ef_sc_hd__decap_12
X_378_ rf.regs\[25\]\[4\] _207_ _208_ VGND VGND VPWR VPWR _209_ sky130_fd_sc_hd__o21ai_2
X_447_ clknet_1_1__leaf_CLK100MHZ _013_ VGND VGND VPWR VPWR rf.regs\[10\]\[0\] sky130_fd_sc_hd__dfxtp_1
XTAP_TAPCELL_ROW_0_56 VGND VPWR sky130_fd_sc_hd__tapvpwrvgnd_1
XTAP_TAPCELL_ROW_9_87 VGND VPWR sky130_fd_sc_hd__tapvpwrvgnd_1
XFILLER_0_25_93 VPWR VGND VPWR VGND sky130_ef_sc_hd__decap_12
X_232_ imem.address\[1\] rf.regs\[5\]\[0\] _066_ _060_ VGND VGND VPWR VPWR _074_ sky130_fd_sc_hd__and4bb_1
X_301_ rf.regs\[0\]\[2\] _092_ _091_ VGND VGND VPWR VPWR _143_ sky130_fd_sc_hd__a21oi_1
XFILLER_0_11_62 VPWR VGND VPWR VGND sky130_ef_sc_hd__decap_12
XFILLER_0_21_109 VGND VGND VPWR VPWR sky130_fd_sc_hd__decap_3
XFILLER_0_16_29 VPWR VGND VPWR VGND sky130_ef_sc_hd__decap_12
XFILLER_0_20_186 VGND VGND VPWR VPWR sky130_fd_sc_hd__fill_1
X_215_ imem.address\[2\] VGND VGND VPWR VPWR _060_ sky130_fd_sc_hd__clkbuf_4
XTAP_TAPCELL_ROW_6_77 VGND VPWR sky130_fd_sc_hd__tapvpwrvgnd_1
XTAP_TAPCELL_ROW_26_137 VGND VPWR sky130_fd_sc_hd__tapvpwrvgnd_1
XFILLER_0_22_83 VGND VGND VPWR VPWR sky130_fd_sc_hd__fill_1
XFILLER_0_7_125 VPWR VGND VPWR VGND sky130_ef_sc_hd__decap_12
XTAP_TAPCELL_ROW_23_129 VGND VPWR sky130_fd_sc_hd__tapvpwrvgnd_1
XFILLER_0_23_7 VPWR VGND VPWR VGND sky130_ef_sc_hd__decap_12
XFILLER_0_7_38 VPWR VGND VPWR VGND sky130_ef_sc_hd__decap_12
XFILLER_0_7_9 VGND VGND VPWR VPWR sky130_fd_sc_hd__fill_1
XFILLER_0_0_164 VGND VGND VPWR VPWR sky130_fd_sc_hd__decap_4
XFILLER_0_8_81 VGND VGND VPWR VPWR sky130_fd_sc_hd__decap_3
XFILLER_0_24_29 VPWR VGND VPWR VGND sky130_ef_sc_hd__decap_12
XFILLER_0_24_18 VGND VGND VPWR VPWR sky130_fd_sc_hd__decap_8
X_463_ clknet_1_0__leaf_CLK100MHZ _029_ _001_ VGND VGND VPWR VPWR imem.address\[1\]
+ sky130_fd_sc_hd__dfrtp_4
X_394_ _036_ VGND VGND VPWR VPWR _011_ sky130_fd_sc_hd__buf_1
XTAP_TAPCELL_ROW_13_98 VGND VPWR sky130_fd_sc_hd__tapvpwrvgnd_1
XFILLER_0_14_40 VGND VGND VPWR VPWR sky130_fd_sc_hd__fill_1
XFILLER_0_27_137 VGND VGND VPWR VPWR sky130_fd_sc_hd__decap_3
X_377_ rf.regs\[10\]\[4\] _078_ _092_ rf.regs\[0\]\[4\] _091_ VGND VGND VPWR VPWR
+ _208_ sky130_fd_sc_hd__a221o_1
X_446_ clknet_1_1__leaf_CLK100MHZ _012_ VGND VGND VPWR VPWR rf.regs\[15\]\[4\] sky130_fd_sc_hd__dfxtp_1
XTAP_TAPCELL_ROW_0_57 VGND VPWR sky130_fd_sc_hd__tapvpwrvgnd_1
XFILLER_0_3_3 VGND VGND VPWR VPWR sky130_fd_sc_hd__decap_4
XTAP_TAPCELL_ROW_9_88 VGND VPWR sky130_fd_sc_hd__tapvpwrvgnd_1
Xtop_module_10 VGND VGND VPWR VPWR top_module_10/HI an[0] sky130_fd_sc_hd__conb_1
XFILLER_0_26_181 VGND VGND VPWR VPWR sky130_fd_sc_hd__decap_3
X_300_ rf.regs\[10\]\[2\] _106_ VGND VGND VPWR VPWR _142_ sky130_fd_sc_hd__nand2_1
XFILLER_0_17_181 VGND VGND VPWR VPWR sky130_fd_sc_hd__decap_6
X_231_ _072_ VGND VGND VPWR VPWR _073_ sky130_fd_sc_hd__clkbuf_2
X_429_ _057_ VGND VGND VPWR VPWR _025_ sky130_fd_sc_hd__buf_1
XFILLER_0_23_184 VGND VGND VPWR VPWR sky130_fd_sc_hd__decap_3
XFILLER_0_11_74 VGND VGND VPWR VPWR sky130_fd_sc_hd__fill_1
Xinput1 BTNR VGND VGND VPWR VPWR net1 sky130_fd_sc_hd__clkbuf_2
XPHY_EDGE_ROW_27_Left_55 VGND VGND VPWR VPWR sky130_fd_sc_hd__decap_3
XTAP_TAPCELL_ROW_6_78 VGND VPWR sky130_fd_sc_hd__tapvpwrvgnd_1
XPHY_EDGE_ROW_11_Left_39 VGND VGND VPWR VPWR sky130_fd_sc_hd__decap_3
XTAP_TAPCELL_ROW_26_138 VGND VPWR sky130_fd_sc_hd__tapvpwrvgnd_1
XFILLER_0_2_83 VGND VGND VPWR VPWR sky130_fd_sc_hd__fill_1
XFILLER_0_7_104 VGND VGND VPWR VPWR sky130_fd_sc_hd__decap_8
XFILLER_0_7_137 VPWR VGND VPWR VGND sky130_ef_sc_hd__decap_12
XTAP_TAPCELL_ROW_3_68 VGND VPWR sky130_fd_sc_hd__tapvpwrvgnd_1
XPHY_EDGE_ROW_9_Right_9 VGND VGND VPWR VPWR sky130_fd_sc_hd__decap_3
XPHY_EDGE_ROW_14_Left_42 VGND VGND VPWR VPWR sky130_fd_sc_hd__decap_3
XFILLER_0_0_176 VGND VGND VPWR VPWR sky130_fd_sc_hd__decap_8
X_393_ rf.regs\[15\]\[3\] _174_ _032_ VGND VGND VPWR VPWR _036_ sky130_fd_sc_hd__mux2_1
XFILLER_0_4_29 VPWR VGND VPWR VGND sky130_ef_sc_hd__decap_12
X_462_ clknet_1_1__leaf_CLK100MHZ _028_ _000_ VGND VGND VPWR VPWR imem.address\[0\]
+ sky130_fd_sc_hd__dfrtp_2
XTAP_TAPCELL_ROW_13_99 VGND VPWR sky130_fd_sc_hd__tapvpwrvgnd_1
XFILLER_0_14_85 VGND VGND VPWR VPWR sky130_fd_sc_hd__decap_3
XTAP_TAPCELL_ROW_0_58 VGND VPWR sky130_fd_sc_hd__tapvpwrvgnd_1
Xtop_module_11 VGND VGND VPWR VPWR an[1] top_module_11/LO sky130_fd_sc_hd__conb_1
XFILLER_0_18_127 VPWR VGND VPWR VGND sky130_ef_sc_hd__decap_12
X_445_ clknet_1_1__leaf_CLK100MHZ _011_ VGND VGND VPWR VPWR rf.regs\[15\]\[3\] sky130_fd_sc_hd__dfxtp_1
X_376_ _093_ VGND VGND VPWR VPWR _207_ sky130_fd_sc_hd__buf_1
X_230_ imem.address\[2\] imem.address\[0\] imem.address\[1\] VGND VGND VPWR VPWR _072_
+ sky130_fd_sc_hd__nor3b_2
XFILLER_0_5_50 VGND VGND VPWR VPWR sky130_fd_sc_hd__fill_2
X_428_ rf.regs\[5\]\[2\] _157_ _054_ VGND VGND VPWR VPWR _057_ sky130_fd_sc_hd__mux2_1
X_359_ _138_ _190_ _174_ _191_ VGND VGND VPWR VPWR _195_ sky130_fd_sc_hd__a211o_1
XFILLER_0_11_31 VGND VGND VPWR VPWR sky130_fd_sc_hd__fill_1
XFILLER_0_14_141 VPWR VGND VPWR VGND sky130_ef_sc_hd__decap_12
Xinput2 BTNU VGND VGND VPWR VPWR net2 sky130_fd_sc_hd__buf_2
XTAP_TAPCELL_ROW_10_89 VGND VPWR sky130_fd_sc_hd__tapvpwrvgnd_1
XPHY_EDGE_ROW_2_Left_30 VGND VGND VPWR VPWR sky130_fd_sc_hd__decap_3
XTAP_TAPCELL_ROW_6_79 VGND VPWR sky130_fd_sc_hd__tapvpwrvgnd_1
XFILLER_0_22_85 VPWR VGND VPWR VGND sky130_ef_sc_hd__decap_12
XFILLER_0_22_41 VPWR VGND VPWR VGND sky130_ef_sc_hd__decap_12
XFILLER_0_7_149 VPWR VGND VPWR VGND sky130_ef_sc_hd__decap_12
XTAP_TAPCELL_ROW_26_139 VGND VPWR sky130_fd_sc_hd__tapvpwrvgnd_1
XTAP_TAPCELL_ROW_3_69 VGND VPWR sky130_fd_sc_hd__tapvpwrvgnd_1
Xclkbuf_0_CLK100MHZ CLK100MHZ VGND VGND VPWR VPWR clknet_0_CLK100MHZ sky130_fd_sc_hd__clkbuf_16
X_461_ clknet_1_0__leaf_CLK100MHZ _027_ VGND VGND VPWR VPWR rf.regs\[5\]\[4\] sky130_fd_sc_hd__dfxtp_1
X_392_ _035_ VGND VGND VPWR VPWR _010_ sky130_fd_sc_hd__clkbuf_1
XTAP_TAPCELL_ROW_0_59 VGND VPWR sky130_fd_sc_hd__tapvpwrvgnd_1
XFILLER_0_27_106 VGND VGND VPWR VPWR sky130_fd_sc_hd__decap_6
Xtop_module_12 VGND VGND VPWR VPWR an[2] top_module_12/LO sky130_fd_sc_hd__conb_1
X_375_ _179_ _181_ _205_ VGND VGND VPWR VPWR _206_ sky130_fd_sc_hd__o21a_1
X_444_ clknet_1_1__leaf_CLK100MHZ _010_ VGND VGND VPWR VPWR rf.regs\[15\]\[2\] sky130_fd_sc_hd__dfxtp_1
XFILLER_0_18_139 VGND VGND VPWR VPWR sky130_fd_sc_hd__fill_1
XFILLER_0_18_117 VGND VGND VPWR VPWR sky130_fd_sc_hd__decap_4
XFILLER_0_5_73 VPWR VGND VPWR VGND sky130_ef_sc_hd__decap_12
X_358_ _174_ _185_ _191_ _189_ VGND VGND VPWR VPWR net8 sky130_fd_sc_hd__o31ai_2
X_427_ _056_ VGND VGND VPWR VPWR _024_ sky130_fd_sc_hd__clkbuf_1
XPHY_EDGE_ROW_27_Right_27 VGND VGND VPWR VPWR sky130_fd_sc_hd__decap_3
XPHY_EDGE_ROW_18_Right_18 VGND VGND VPWR VPWR sky130_fd_sc_hd__decap_3
X_289_ _061_ rf.regs\[15\]\[2\] _124_ VGND VGND VPWR VPWR _131_ sky130_fd_sc_hd__o21a_1
XFILLER_0_11_54 VGND VGND VPWR VPWR sky130_fd_sc_hd__fill_2
XFILLER_0_20_101 VGND VGND VPWR VPWR sky130_fd_sc_hd__fill_2
XFILLER_0_14_153 VPWR VGND VPWR VGND sky130_ef_sc_hd__decap_12
XFILLER_0_22_97 VGND VGND VPWR VPWR sky130_fd_sc_hd__fill_1
XFILLER_0_22_53 VPWR VGND VPWR VGND sky130_ef_sc_hd__decap_12
XFILLER_0_20_145 VPWR VGND VPWR VGND sky130_ef_sc_hd__decap_12
XFILLER_0_11_189 VGND VGND VPWR VPWR sky130_fd_sc_hd__fill_1
XFILLER_0_11_167 VGND VGND VPWR VPWR sky130_fd_sc_hd__fill_1
XFILLER_0_2_96 VGND VGND VPWR VPWR sky130_fd_sc_hd__decap_6
XFILLER_0_2_85 VGND VGND VPWR VPWR sky130_fd_sc_hd__decap_6
XFILLER_0_2_41 VPWR VGND VPWR VGND sky130_ef_sc_hd__decap_12
XFILLER_0_6_172 VPWR VGND VPWR VGND sky130_ef_sc_hd__decap_12
XFILLER_0_7_19 VGND VGND VPWR VPWR sky130_fd_sc_hd__decap_3
XPHY_EDGE_ROW_0_Right_0 VGND VGND VPWR VPWR sky130_fd_sc_hd__decap_3
XFILLER_0_0_123 VPWR VGND VPWR VGND sky130_ef_sc_hd__decap_12
X_460_ clknet_1_0__leaf_CLK100MHZ _026_ VGND VGND VPWR VPWR rf.regs\[5\]\[3\] sky130_fd_sc_hd__dfxtp_1
XFILLER_0_8_73 VGND VGND VPWR VPWR sky130_fd_sc_hd__fill_1
X_391_ rf.regs\[15\]\[2\] _157_ _032_ VGND VGND VPWR VPWR _035_ sky130_fd_sc_hd__mux2_1
XFILLER_0_14_54 VGND VGND VPWR VPWR sky130_fd_sc_hd__fill_1
XFILLER_0_12_3 VPWR VGND VPWR VGND sky130_ef_sc_hd__decap_12
Xtop_module_13 VGND VGND VPWR VPWR an[3] top_module_13/LO sky130_fd_sc_hd__conb_1
X_374_ _179_ _181_ _089_ VGND VGND VPWR VPWR _205_ sky130_fd_sc_hd__a21oi_1
X_443_ clknet_1_0__leaf_CLK100MHZ _009_ VGND VGND VPWR VPWR rf.regs\[15\]\[1\] sky130_fd_sc_hd__dfxtp_1
XFILLER_0_26_173 VGND VGND VPWR VPWR sky130_fd_sc_hd__decap_8
XFILLER_0_25_31 VGND VGND VPWR VPWR sky130_fd_sc_hd__decap_8
XFILLER_0_5_85 VPWR VGND VPWR VGND sky130_ef_sc_hd__decap_12
XFILLER_0_17_151 VGND VGND VPWR VPWR sky130_fd_sc_hd__fill_1
XFILLER_0_1_3 VPWR VGND VPWR VGND sky130_ef_sc_hd__decap_12
X_288_ rf.regs\[0\]\[2\] _071_ _073_ _129_ VGND VGND VPWR VPWR _130_ sky130_fd_sc_hd__a211o_1
XFILLER_0_23_176 VGND VGND VPWR VPWR sky130_fd_sc_hd__decap_8
X_426_ rf.regs\[5\]\[1\] _138_ _054_ VGND VGND VPWR VPWR _056_ sky130_fd_sc_hd__mux2_1
X_357_ _193_ _157_ _184_ _188_ VGND VGND VPWR VPWR net7 sky130_fd_sc_hd__a211o_1
XFILLER_0_11_11 VGND VGND VPWR VPWR sky130_fd_sc_hd__fill_2
XFILLER_0_14_165 VGND VGND VPWR VPWR sky130_fd_sc_hd__fill_1
XFILLER_0_14_132 VGND VGND VPWR VPWR sky130_fd_sc_hd__fill_1
XFILLER_0_9_181 VGND VGND VPWR VPWR sky130_fd_sc_hd__fill_1
XFILLER_0_22_65 VPWR VGND VPWR VGND sky130_ef_sc_hd__decap_12
XFILLER_0_20_168 VPWR VGND VPWR VGND sky130_ef_sc_hd__decap_12
XFILLER_0_20_157 VGND VGND VPWR VPWR sky130_fd_sc_hd__decap_8
X_409_ _045_ VGND VGND VPWR VPWR _017_ sky130_fd_sc_hd__clkbuf_1
XFILLER_0_11_113 VGND VGND VPWR VPWR sky130_fd_sc_hd__fill_2
XFILLER_0_2_53 VPWR VGND VPWR VGND sky130_ef_sc_hd__decap_12
XFILLER_0_2_20 VGND VGND VPWR VPWR sky130_fd_sc_hd__decap_8
XFILLER_0_6_184 VGND VGND VPWR VPWR sky130_fd_sc_hd__decap_6
XFILLER_0_3_165 VGND VGND VPWR VPWR sky130_fd_sc_hd__decap_3
XTAP_TAPCELL_ROW_7_80 VGND VPWR sky130_fd_sc_hd__tapvpwrvgnd_1
XTAP_TAPCELL_ROW_13_100 VGND VPWR sky130_fd_sc_hd__tapvpwrvgnd_1
XFILLER_0_14_7 VGND VGND VPWR VPWR sky130_fd_sc_hd__decap_8
XFILLER_0_0_135 VGND VGND VPWR VPWR sky130_fd_sc_hd__decap_4
XFILLER_0_0_113 VGND VGND VPWR VPWR sky130_fd_sc_hd__decap_6
X_390_ _034_ VGND VGND VPWR VPWR _009_ sky130_fd_sc_hd__buf_1
XFILLER_0_8_41 VPWR VGND VPWR VGND sky130_ef_sc_hd__decap_12
XFILLER_0_8_85 VPWR VGND VPWR VGND sky130_ef_sc_hd__decap_12
XPHY_EDGE_ROW_18_Left_46 VGND VGND VPWR VPWR sky130_fd_sc_hd__decap_3
X_373_ _161_ _168_ _166_ VGND VGND VPWR VPWR _204_ sky130_fd_sc_hd__a21oi_2
X_442_ clknet_1_1__leaf_CLK100MHZ _008_ VGND VGND VPWR VPWR rf.regs\[15\]\[0\] sky130_fd_sc_hd__dfxtp_1
XFILLER_0_3_7 VGND VGND VPWR VPWR sky130_fd_sc_hd__fill_1
XFILLER_0_26_163 VGND VGND VPWR VPWR sky130_fd_sc_hd__fill_1
XFILLER_0_26_141 VGND VGND VPWR VPWR sky130_fd_sc_hd__decap_8
XFILLER_0_5_42 VGND VGND VPWR VPWR sky130_fd_sc_hd__fill_1
XFILLER_0_5_97 VPWR VGND VPWR VGND sky130_ef_sc_hd__decap_12
XFILLER_0_23_111 VGND VGND VPWR VPWR sky130_fd_sc_hd__fill_1
X_287_ imem.address\[1\] _066_ rf.regs\[5\]\[2\] _060_ VGND VGND VPWR VPWR _129_ sky130_fd_sc_hd__and4b_1
X_356_ _187_ _192_ _194_ _188_ VGND VGND VPWR VPWR net6 sky130_fd_sc_hd__a31o_1
X_425_ _055_ VGND VGND VPWR VPWR _023_ sky130_fd_sc_hd__clkbuf_1
XFILLER_0_14_111 VGND VGND VPWR VPWR sky130_fd_sc_hd__fill_2
X_408_ _213_ rf.regs\[10\]\[4\] _040_ VGND VGND VPWR VPWR _045_ sky130_fd_sc_hd__mux2_1
XFILLER_0_22_77 VGND VGND VPWR VPWR sky130_fd_sc_hd__decap_6
XFILLER_0_11_169 VPWR VGND VPWR VGND sky130_ef_sc_hd__decap_12
XFILLER_0_11_103 VGND VGND VPWR VPWR sky130_fd_sc_hd__decap_4
X_339_ _180_ VGND VGND VPWR VPWR _181_ sky130_fd_sc_hd__dlymetal6s2s_1
XFILLER_0_2_65 VPWR VGND VPWR VGND sky130_ef_sc_hd__decap_12
XFILLER_0_6_130 VGND VGND VPWR VPWR sky130_fd_sc_hd__decap_8
XFILLER_0_6_141 VGND VGND VPWR VPWR sky130_fd_sc_hd__fill_1
XPHY_EDGE_ROW_6_Left_34 VGND VGND VPWR VPWR sky130_fd_sc_hd__decap_3
XFILLER_0_3_111 VGND VGND VPWR VPWR sky130_fd_sc_hd__fill_1
XFILLER_0_3_133 VPWR VGND VPWR VGND sky130_ef_sc_hd__decap_12
XFILLER_0_3_188 VGND VGND VPWR VPWR sky130_fd_sc_hd__fill_2
XTAP_TAPCELL_ROW_7_81 VGND VPWR sky130_fd_sc_hd__tapvpwrvgnd_1
XFILLER_0_8_53 VPWR VGND VPWR VGND sky130_ef_sc_hd__decap_12
XFILLER_0_8_97 VGND VGND VPWR VPWR sky130_fd_sc_hd__decap_4
XTAP_TAPCELL_ROW_4_71 VGND VPWR sky130_fd_sc_hd__tapvpwrvgnd_1
X_441_ clknet_1_0__leaf_CLK100MHZ _007_ VGND VGND VPWR VPWR rf.regs\[25\]\[4\] sky130_fd_sc_hd__dfxtp_1
X_372_ _203_ VGND VGND VPWR VPWR _006_ sky130_fd_sc_hd__buf_1
XFILLER_0_25_44 VPWR VGND VPWR VGND sky130_ef_sc_hd__decap_12
X_355_ _193_ _184_ _157_ VGND VGND VPWR VPWR _194_ sky130_fd_sc_hd__a21o_1
X_424_ rf.regs\[5\]\[0\] _184_ _054_ VGND VGND VPWR VPWR _055_ sky130_fd_sc_hd__mux2_1
X_286_ _124_ _126_ _127_ _101_ VGND VGND VPWR VPWR _128_ sky130_fd_sc_hd__a31oi_4
XPHY_EDGE_ROW_23_Right_23 VGND VGND VPWR VPWR sky130_fd_sc_hd__decap_3
XFILLER_0_20_137 VGND VGND VPWR VPWR sky130_fd_sc_hd__decap_3
XFILLER_0_20_115 VGND VGND VPWR VPWR sky130_fd_sc_hd__fill_1
XPHY_EDGE_ROW_14_Right_14 VGND VGND VPWR VPWR sky130_fd_sc_hd__decap_3
XPHY_EDGE_ROW_22_Left_50 VGND VGND VPWR VPWR sky130_fd_sc_hd__decap_3
X_338_ _081_ _103_ _128_ _133_ VGND VGND VPWR VPWR _180_ sky130_fd_sc_hd__and4_1
XFILLER_0_11_159 VGND VGND VPWR VPWR sky130_fd_sc_hd__decap_8
XFILLER_0_11_137 VGND VGND VPWR VPWR sky130_fd_sc_hd__fill_2
XFILLER_0_2_77 VGND VGND VPWR VPWR sky130_fd_sc_hd__decap_6
X_269_ _109_ _110_ VGND VGND VPWR VPWR _111_ sky130_fd_sc_hd__or2b_1
X_407_ _044_ VGND VGND VPWR VPWR _016_ sky130_fd_sc_hd__clkbuf_1
XTAP_TAPCELL_ROW_11_92 VGND VPWR sky130_fd_sc_hd__tapvpwrvgnd_1
XFILLER_0_17_89 VGND VGND VPWR VPWR sky130_fd_sc_hd__decap_3
XTAP_TAPCELL_ROW_7_82 VGND VPWR sky130_fd_sc_hd__tapvpwrvgnd_1
XFILLER_0_3_145 VPWR VGND VPWR VGND sky130_ef_sc_hd__decap_12
XPHY_EDGE_ROW_4_Right_4 VGND VGND VPWR VPWR sky130_fd_sc_hd__decap_3
XFILLER_0_8_65 VGND VGND VPWR VPWR sky130_fd_sc_hd__decap_8
XTAP_TAPCELL_ROW_4_72 VGND VPWR sky130_fd_sc_hd__tapvpwrvgnd_1
X_440_ clknet_1_0__leaf_CLK100MHZ _006_ VGND VGND VPWR VPWR rf.regs\[25\]\[3\] sky130_fd_sc_hd__dfxtp_1
X_371_ rf.regs\[25\]\[3\] _174_ _199_ VGND VGND VPWR VPWR _203_ sky130_fd_sc_hd__mux2_1
XFILLER_0_26_121 VPWR VGND VPWR VGND sky130_ef_sc_hd__decap_12
XFILLER_0_5_11 VGND VGND VPWR VPWR sky130_fd_sc_hd__fill_2
XFILLER_0_10_3 VGND VGND VPWR VPWR sky130_fd_sc_hd__decap_4
X_285_ _066_ rf.regs\[15\]\[3\] _099_ VGND VGND VPWR VPWR _127_ sky130_fd_sc_hd__or3_2
X_354_ _193_ _157_ _184_ _189_ VGND VGND VPWR VPWR net5 sky130_fd_sc_hd__o31ai_1
X_423_ _053_ VGND VGND VPWR VPWR _054_ sky130_fd_sc_hd__clkbuf_2
XFILLER_0_14_179 VGND VGND VPWR VPWR sky130_fd_sc_hd__decap_8
XFILLER_0_14_124 VGND VGND VPWR VPWR sky130_fd_sc_hd__fill_1
XTAP_TAPCELL_ROW_1_62 VGND VPWR sky130_fd_sc_hd__tapvpwrvgnd_1
XFILLER_0_22_13 VGND VGND VPWR VPWR sky130_fd_sc_hd__fill_2
X_337_ _178_ VGND VGND VPWR VPWR _179_ sky130_fd_sc_hd__dlymetal6s2s_1
X_268_ _089_ _108_ _104_ VGND VGND VPWR VPWR _110_ sky130_fd_sc_hd__or3_2
X_406_ _174_ rf.regs\[10\]\[3\] _040_ VGND VGND VPWR VPWR _044_ sky130_fd_sc_hd__mux2_1
XTAP_TAPCELL_ROW_11_93 VGND VPWR sky130_fd_sc_hd__tapvpwrvgnd_1
XFILLER_0_6_121 VGND VGND VPWR VPWR sky130_fd_sc_hd__fill_1
XFILLER_0_6_154 VPWR VGND VPWR VGND sky130_ef_sc_hd__decap_12
XFILLER_0_10_160 VGND VGND VPWR VPWR sky130_fd_sc_hd__decap_8
XFILLER_0_17_57 VPWR VGND VPWR VGND sky130_ef_sc_hd__decap_12
XTAP_TAPCELL_ROW_22_125 VGND VPWR sky130_fd_sc_hd__tapvpwrvgnd_1
XFILLER_0_3_102 VGND VGND VPWR VPWR sky130_fd_sc_hd__fill_1
XFILLER_0_3_157 VGND VGND VPWR VPWR sky130_fd_sc_hd__decap_8
XFILLER_0_14_58 VGND VGND VPWR VPWR sky130_fd_sc_hd__fill_2
XFILLER_0_14_36 VGND VGND VPWR VPWR sky130_fd_sc_hd__decap_4
XTAP_TAPCELL_ROW_4_73 VGND VPWR sky130_fd_sc_hd__tapvpwrvgnd_1
XFILLER_0_25_57 VPWR VGND VPWR VGND sky130_ef_sc_hd__decap_12
X_370_ _202_ VGND VGND VPWR VPWR _005_ sky130_fd_sc_hd__clkbuf_1
XFILLER_0_26_133 VGND VGND VPWR VPWR sky130_fd_sc_hd__decap_6
X_422_ _064_ net2 _080_ VGND VGND VPWR VPWR _053_ sky130_fd_sc_hd__and3_1
XFILLER_0_17_111 VGND VGND VPWR VPWR sky130_fd_sc_hd__fill_1
X_284_ rf.regs\[0\]\[3\] _071_ _072_ _125_ VGND VGND VPWR VPWR _126_ sky130_fd_sc_hd__a211o_1
X_353_ _138_ VGND VGND VPWR VPWR _193_ sky130_fd_sc_hd__inv_2
XFILLER_0_23_169 VGND VGND VPWR VPWR sky130_fd_sc_hd__decap_4
XFILLER_0_23_125 VGND VGND VPWR VPWR sky130_fd_sc_hd__decap_3
XTAP_TAPCELL_ROW_1_63 VGND VPWR sky130_fd_sc_hd__tapvpwrvgnd_1
XFILLER_0_22_25 VGND VGND VPWR VPWR sky130_fd_sc_hd__decap_3
X_267_ _089_ _104_ _108_ VGND VGND VPWR VPWR _109_ sky130_fd_sc_hd__o21a_1
X_336_ rf.regs\[0\]\[4\] _175_ _176_ _177_ VGND VGND VPWR VPWR _178_ sky130_fd_sc_hd__o211ai_1
X_405_ _043_ VGND VGND VPWR VPWR _015_ sky130_fd_sc_hd__buf_1
XFILLER_0_6_166 VGND VGND VPWR VPWR sky130_fd_sc_hd__decap_3
XTAP_TAPCELL_ROW_25_134 VGND VPWR sky130_fd_sc_hd__tapvpwrvgnd_1
XFILLER_0_17_69 VPWR VGND VPWR VGND sky130_ef_sc_hd__decap_12
XTAP_TAPCELL_ROW_11_94 VGND VPWR sky130_fd_sc_hd__tapvpwrvgnd_1
X_319_ _152_ _154_ _160_ VGND VGND VPWR VPWR _161_ sky130_fd_sc_hd__o21ai_2
XTAP_TAPCELL_ROW_22_126 VGND VPWR sky130_fd_sc_hd__tapvpwrvgnd_1
XFILLER_0_2_180 VGND VGND VPWR VPWR sky130_fd_sc_hd__fill_1
XFILLER_0_0_139 VGND VGND VPWR VPWR sky130_fd_sc_hd__fill_1
XFILLER_0_14_48 VGND VGND VPWR VPWR sky130_fd_sc_hd__decap_6
XFILLER_0_14_26 VGND VGND VPWR VPWR sky130_fd_sc_hd__fill_2
XFILLER_0_14_15 VGND VGND VPWR VPWR sky130_fd_sc_hd__fill_2
XFILLER_0_25_69 VPWR VGND VPWR VGND sky130_ef_sc_hd__decap_12
XFILLER_0_5_46 VGND VGND VPWR VPWR sky130_fd_sc_hd__fill_2
X_421_ _052_ VGND VGND VPWR VPWR _022_ sky130_fd_sc_hd__clkbuf_1
XFILLER_0_17_123 VPWR VGND VPWR VGND sky130_ef_sc_hd__decap_12
XFILLER_0_17_101 VGND VGND VPWR VPWR sky130_fd_sc_hd__fill_1
XFILLER_0_23_148 VPWR VGND VPWR VGND sky130_ef_sc_hd__decap_12
X_352_ _189_ _192_ VGND VGND VPWR VPWR net4 sky130_fd_sc_hd__nand2_1
X_283_ imem.address\[1\] imem.address\[0\] rf.regs\[5\]\[3\] _060_ VGND VGND VPWR
+ VPWR _125_ sky130_fd_sc_hd__and4b_1
XTAP_TAPCELL_ROW_1_64 VGND VPWR sky130_fd_sc_hd__tapvpwrvgnd_1
XFILLER_0_11_38 VPWR VGND VPWR VGND sky130_ef_sc_hd__decap_12
X_335_ _067_ rf.regs\[15\]\[4\] _099_ _124_ VGND VGND VPWR VPWR _177_ sky130_fd_sc_hd__o31a_1
XFILLER_0_20_129 VGND VGND VPWR VPWR sky130_fd_sc_hd__decap_8
X_404_ _157_ rf.regs\[10\]\[2\] _040_ VGND VGND VPWR VPWR _043_ sky130_fd_sc_hd__mux2_1
X_266_ rf.regs\[25\]\[1\] _091_ _107_ VGND VGND VPWR VPWR _108_ sky130_fd_sc_hd__a21o_1
XFILLER_0_11_118 VGND VGND VPWR VPWR sky130_fd_sc_hd__decap_8
XFILLER_0_6_145 VGND VGND VPWR VPWR sky130_fd_sc_hd__fill_1
XPHY_EDGE_ROW_10_Right_10 VGND VGND VPWR VPWR sky130_fd_sc_hd__decap_3
XTAP_TAPCELL_ROW_25_135 VGND VPWR sky130_fd_sc_hd__tapvpwrvgnd_1
X_249_ _090_ VGND VGND VPWR VPWR _091_ sky130_fd_sc_hd__clkbuf_2
XPHY_EDGE_ROW_26_Left_54 VGND VGND VPWR VPWR sky130_fd_sc_hd__decap_3
X_318_ _144_ _151_ VGND VGND VPWR VPWR _160_ sky130_fd_sc_hd__or2_1
XFILLER_0_17_48 VGND VGND VPWR VPWR sky130_fd_sc_hd__decap_8
XFILLER_0_17_15 VGND VGND VPWR VPWR sky130_fd_sc_hd__fill_1
XPHY_EDGE_ROW_10_Left_38 VGND VGND VPWR VPWR sky130_fd_sc_hd__decap_3
XTAP_TAPCELL_ROW_22_127 VGND VPWR sky130_fd_sc_hd__tapvpwrvgnd_1
XPHY_EDGE_ROW_8_Right_8 VGND VGND VPWR VPWR sky130_fd_sc_hd__decap_3
XPHY_EDGE_ROW_13_Left_41 VGND VGND VPWR VPWR sky130_fd_sc_hd__decap_3
XFILLER_0_5_36 VGND VGND VPWR VPWR sky130_fd_sc_hd__decap_6
XFILLER_0_17_135 VPWR VGND VPWR VGND sky130_ef_sc_hd__decap_12
X_282_ imem.address\[1\] _060_ _066_ VGND VGND VPWR VPWR _124_ sky130_fd_sc_hd__mux2_2
X_420_ rf.regs\[0\]\[4\] _047_ VGND VGND VPWR VPWR _052_ sky130_fd_sc_hd__and2_1
X_351_ _185_ _191_ VGND VGND VPWR VPWR _192_ sky130_fd_sc_hd__or2b_1
XFILLER_0_26_91 VGND VGND VPWR VPWR sky130_fd_sc_hd__decap_8
X_334_ rf.regs\[5\]\[4\] _105_ VGND VGND VPWR VPWR _176_ sky130_fd_sc_hd__or2_1
X_403_ _042_ VGND VGND VPWR VPWR _014_ sky130_fd_sc_hd__clkbuf_1
XFILLER_0_9_121 VGND VGND VPWR VPWR sky130_fd_sc_hd__fill_2
X_265_ rf.regs\[10\]\[1\] _099_ _106_ rf.regs\[0\]\[1\] _093_ VGND VGND VPWR VPWR
+ _107_ sky130_fd_sc_hd__o221a_1
XTAP_TAPCELL_ROW_25_136 VGND VPWR sky130_fd_sc_hd__tapvpwrvgnd_1
X_248_ _087_ _089_ VGND VGND VPWR VPWR _090_ sky130_fd_sc_hd__or2_1
X_317_ _065_ _067_ _064_ VGND VGND VPWR VPWR _159_ sky130_fd_sc_hd__o21ai_1
XFILLER_0_23_92 VGND VGND VPWR VPWR sky130_fd_sc_hd__decap_3
XFILLER_0_23_81 VGND VGND VPWR VPWR sky130_fd_sc_hd__fill_1
XFILLER_0_0_119 VGND VGND VPWR VPWR sky130_fd_sc_hd__fill_1
XFILLER_0_19_3 VPWR VGND VPWR VGND sky130_ef_sc_hd__decap_12
XFILLER_0_8_36 VGND VGND VPWR VPWR sky130_fd_sc_hd__fill_1
XFILLER_0_20_82 VGND VGND VPWR VPWR sky130_fd_sc_hd__fill_2
XFILLER_0_0_81 VGND VGND VPWR VPWR sky130_fd_sc_hd__decap_3
XFILLER_0_26_114 VGND VGND VPWR VPWR sky130_fd_sc_hd__fill_1
XFILLER_0_8_3 VPWR VGND VPWR VGND sky130_ef_sc_hd__decap_12
XFILLER_0_17_147 VGND VGND VPWR VPWR sky130_fd_sc_hd__decap_4
XFILLER_0_15_82 VPWR VGND VPWR VGND sky130_ef_sc_hd__decap_12
XFILLER_0_10_7 VGND VGND VPWR VPWR sky130_fd_sc_hd__fill_1
X_350_ _138_ _184_ _190_ VGND VGND VPWR VPWR _191_ sky130_fd_sc_hd__a21oi_2
XFILLER_0_23_117 VGND VGND VPWR VPWR sky130_fd_sc_hd__decap_8
X_281_ _116_ _122_ VGND VGND VPWR VPWR _123_ sky130_fd_sc_hd__and2_1
XFILLER_0_14_139 VGND VGND VPWR VPWR sky130_fd_sc_hd__fill_1
XFILLER_0_14_128 VGND VGND VPWR VPWR sky130_fd_sc_hd__decap_4
XFILLER_0_26_70 VGND VGND VPWR VPWR sky130_fd_sc_hd__decap_3
XFILLER_0_13_183 VGND VGND VPWR VPWR sky130_fd_sc_hd__decap_6
XFILLER_0_13_161 VGND VGND VPWR VPWR sky130_fd_sc_hd__decap_6
XFILLER_0_9_111 VGND VGND VPWR VPWR sky130_fd_sc_hd__fill_1
XFILLER_0_22_17 VGND VGND VPWR VPWR sky130_fd_sc_hd__decap_8
X_264_ _105_ _099_ VGND VGND VPWR VPWR _106_ sky130_fd_sc_hd__nand2_2
X_333_ _086_ _073_ VGND VGND VPWR VPWR _175_ sky130_fd_sc_hd__or2_1
X_402_ _138_ rf.regs\[10\]\[1\] _040_ VGND VGND VPWR VPWR _042_ sky130_fd_sc_hd__mux2_1
XFILLER_0_12_83 VGND VGND VPWR VPWR sky130_fd_sc_hd__fill_1
XFILLER_0_12_50 VPWR VGND VPWR VGND sky130_ef_sc_hd__decap_12
XFILLER_0_17_39 VGND VGND VPWR VPWR sky130_fd_sc_hd__decap_6
X_316_ _138_ _157_ VGND VGND VPWR VPWR _158_ sky130_fd_sc_hd__nor2_2
X_247_ _088_ VGND VGND VPWR VPWR _089_ sky130_fd_sc_hd__buf_2
XFILLER_0_0_109 VGND VGND VPWR VPWR sky130_fd_sc_hd__decap_3
XFILLER_0_8_15 VPWR VGND VPWR VGND sky130_ef_sc_hd__decap_12
XFILLER_0_25_39 VGND VGND VPWR VPWR sky130_fd_sc_hd__fill_2
XFILLER_0_15_94 VGND VGND VPWR VPWR sky130_fd_sc_hd__fill_1
XFILLER_0_25_181 VGND VGND VPWR VPWR sky130_fd_sc_hd__decap_8
X_280_ _117_ _121_ _096_ VGND VGND VPWR VPWR _122_ sky130_fd_sc_hd__a21oi_1
XFILLER_0_11_19 VPWR VGND VPWR VGND sky130_ef_sc_hd__decap_12
XFILLER_0_6_70 VPWR VGND VPWR VGND sky130_ef_sc_hd__decap_12
XFILLER_0_9_167 VGND VGND VPWR VPWR sky130_fd_sc_hd__fill_1
XFILLER_0_9_189 VGND VGND VPWR VPWR sky130_fd_sc_hd__fill_1
X_401_ _041_ VGND VGND VPWR VPWR _013_ sky130_fd_sc_hd__buf_1
X_263_ _071_ VGND VGND VPWR VPWR _105_ sky130_fd_sc_hd__dlymetal6s2s_1
XFILLER_0_22_29 VPWR VGND VPWR VGND sky130_ef_sc_hd__decap_12
X_332_ _159_ _169_ _170_ _137_ _173_ VGND VGND VPWR VPWR _174_ sky130_fd_sc_hd__a32o_4
XFILLER_0_12_62 VGND VGND VPWR VPWR sky130_fd_sc_hd__decap_4
Xclkbuf_1_0__f_CLK100MHZ clknet_0_CLK100MHZ VGND VGND VPWR VPWR clknet_1_0__leaf_CLK100MHZ
+ sky130_fd_sc_hd__clkbuf_16
X_246_ _061_ _065_ _067_ VGND VGND VPWR VPWR _088_ sky130_fd_sc_hd__and3b_1
X_315_ _141_ _148_ _155_ _156_ VGND VGND VPWR VPWR _157_ sky130_fd_sc_hd__a2bb2o_4
X_229_ imem.address\[1\] _066_ _060_ VGND VGND VPWR VPWR _071_ sky130_fd_sc_hd__nand3b_4
XFILLER_0_8_27 VGND VGND VPWR VPWR sky130_fd_sc_hd__fill_1
XFILLER_0_18_83 VGND VGND VPWR VPWR sky130_fd_sc_hd__fill_1
XPHY_EDGE_ROW_26_Right_26 VGND VGND VPWR VPWR sky130_fd_sc_hd__decap_3
XPHY_EDGE_ROW_17_Right_17 VGND VGND VPWR VPWR sky130_fd_sc_hd__decap_3
XFILLER_0_9_81 VPWR VGND VPWR VGND sky130_ef_sc_hd__decap_12
XFILLER_0_26_149 VGND VGND VPWR VPWR sky130_fd_sc_hd__fill_2
XPHY_EDGE_ROW_17_Left_45 VGND VGND VPWR VPWR sky130_fd_sc_hd__decap_3
XFILLER_0_22_141 VPWR VGND VPWR VGND sky130_ef_sc_hd__decap_12
XFILLER_0_9_113 VGND VGND VPWR VPWR sky130_fd_sc_hd__decap_8
X_331_ _122_ _172_ _116_ VGND VGND VPWR VPWR _173_ sky130_fd_sc_hd__mux2_1
X_262_ _081_ _103_ VGND VGND VPWR VPWR _104_ sky130_fd_sc_hd__xnor2_2
X_400_ _184_ rf.regs\[10\]\[0\] _040_ VGND VGND VPWR VPWR _041_ sky130_fd_sc_hd__mux2_1
XFILLER_0_6_82 VGND VGND VPWR VPWR sky130_fd_sc_hd__fill_2
XFILLER_0_2_29 VPWR VGND VPWR VGND sky130_ef_sc_hd__decap_12
XFILLER_0_6_149 VGND VGND VPWR VPWR sky130_fd_sc_hd__fill_2
XFILLER_0_6_138 VGND VGND VPWR VPWR sky130_fd_sc_hd__fill_2
X_245_ _086_ VGND VGND VPWR VPWR _087_ sky130_fd_sc_hd__clkbuf_2
X_314_ _152_ _154_ _113_ VGND VGND VPWR VPWR _156_ sky130_fd_sc_hd__a21oi_1
XFILLER_0_2_141 VPWR VGND VPWR VGND sky130_ef_sc_hd__decap_12
XPHY_EDGE_ROW_5_Left_33 VGND VGND VPWR VPWR sky130_fd_sc_hd__decap_3
XFILLER_0_26_7 VPWR VGND VPWR VGND sky130_ef_sc_hd__decap_12
X_228_ rf.regs\[0\]\[0\] VGND VGND VPWR VPWR _070_ sky130_fd_sc_hd__inv_2
XFILLER_0_20_41 VGND VGND VPWR VPWR sky130_fd_sc_hd__decap_4
XFILLER_0_17_3 VPWR VGND VPWR VGND sky130_ef_sc_hd__decap_12
XFILLER_0_9_93 VGND VGND VPWR VPWR sky130_fd_sc_hd__decap_6
XFILLER_0_26_139 VGND VGND VPWR VPWR sky130_fd_sc_hd__fill_1
XFILLER_0_26_106 VGND VGND VPWR VPWR sky130_fd_sc_hd__decap_8
XFILLER_0_25_19 VPWR VGND VPWR VGND sky130_ef_sc_hd__decap_12
XFILLER_0_25_150 VGND VGND VPWR VPWR sky130_fd_sc_hd__decap_6
XFILLER_0_22_153 VPWR VGND VPWR VGND sky130_ef_sc_hd__decap_12
XFILLER_0_22_120 VGND VGND VPWR VPWR sky130_fd_sc_hd__fill_1
XFILLER_0_9_103 VGND VGND VPWR VPWR sky130_fd_sc_hd__decap_8
XFILLER_0_9_169 VPWR VGND VPWR VGND sky130_ef_sc_hd__decap_12
X_261_ _076_ _098_ _100_ _102_ VGND VGND VPWR VPWR _103_ sky130_fd_sc_hd__a31oi_4
XFILLER_0_8_180 VGND VGND VPWR VPWR sky130_fd_sc_hd__decap_3
X_330_ _171_ _163_ _083_ VGND VGND VPWR VPWR _172_ sky130_fd_sc_hd__mux2_1
X_459_ clknet_1_0__leaf_CLK100MHZ _025_ VGND VGND VPWR VPWR rf.regs\[5\]\[2\] sky130_fd_sc_hd__dfxtp_1
XFILLER_0_10_178 VGND VGND VPWR VPWR sky130_fd_sc_hd__decap_3
XTAP_TAPCELL_ROW_16_107 VGND VPWR sky130_fd_sc_hd__tapvpwrvgnd_1
X_313_ _152_ _154_ VGND VGND VPWR VPWR _155_ sky130_fd_sc_hd__or2_1
X_244_ _085_ VGND VGND VPWR VPWR _086_ sky130_fd_sc_hd__buf_1
XFILLER_0_2_164 VPWR VGND VPWR VGND sky130_ef_sc_hd__decap_12
XFILLER_0_2_153 VGND VGND VPWR VPWR sky130_fd_sc_hd__decap_6
XFILLER_0_3_62 VPWR VGND VPWR VGND sky130_ef_sc_hd__decap_12
XFILLER_0_18_85 VGND VGND VPWR VPWR sky130_fd_sc_hd__decap_4
XFILLER_0_18_41 VPWR VGND VPWR VGND sky130_ef_sc_hd__decap_12
X_227_ net2 _067_ VGND VGND VPWR VPWR _028_ sky130_fd_sc_hd__xor2_1
XFILLER_0_0_85 VPWR VGND VPWR VGND sky130_ef_sc_hd__decap_12
XPHY_EDGE_ROW_3_Right_3 VGND VGND VPWR VPWR sky130_fd_sc_hd__decap_3
XFILLER_0_25_162 VGND VGND VPWR VPWR sky130_fd_sc_hd__decap_6
XFILLER_0_17_107 VGND VGND VPWR VPWR sky130_fd_sc_hd__decap_4
XFILLER_0_16_162 VGND VGND VPWR VPWR sky130_fd_sc_hd__fill_2
XFILLER_0_22_165 VPWR VGND VPWR VGND sky130_ef_sc_hd__decap_12
X_260_ _080_ _101_ VGND VGND VPWR VPWR _102_ sky130_fd_sc_hd__or2_2
XFILLER_0_9_126 VPWR VGND VPWR VGND sky130_ef_sc_hd__decap_12
XFILLER_0_9_159 VGND VGND VPWR VPWR sky130_fd_sc_hd__decap_8
XTAP_TAPCELL_ROW_19_116 VGND VPWR sky130_fd_sc_hd__tapvpwrvgnd_1
X_458_ clknet_1_1__leaf_CLK100MHZ _024_ VGND VGND VPWR VPWR rf.regs\[5\]\[1\] sky130_fd_sc_hd__dfxtp_1
X_389_ rf.regs\[15\]\[1\] _138_ _032_ VGND VGND VPWR VPWR _034_ sky130_fd_sc_hd__mux2_1
XFILLER_0_10_168 VGND VGND VPWR VPWR sky130_fd_sc_hd__fill_2
X_243_ _065_ _066_ _060_ VGND VGND VPWR VPWR _085_ sky130_fd_sc_hd__and3b_1
X_312_ _153_ _110_ _109_ VGND VGND VPWR VPWR _154_ sky130_fd_sc_hd__a21oi_2
XTAP_TAPCELL_ROW_16_108 VGND VPWR sky130_fd_sc_hd__tapvpwrvgnd_1
XFILLER_0_23_31 VPWR VGND VPWR VGND sky130_ef_sc_hd__decap_12
XFILLER_0_2_176 VGND VGND VPWR VPWR sky130_fd_sc_hd__decap_4
XTAP_TAPCELL_ROW_21_122 VGND VPWR sky130_fd_sc_hd__tapvpwrvgnd_1
XFILLER_0_3_30 VGND VGND VPWR VPWR sky130_fd_sc_hd__decap_4
XFILLER_0_3_41 VGND VGND VPWR VPWR sky130_fd_sc_hd__decap_8
XFILLER_0_3_74 VPWR VGND VPWR VGND sky130_ef_sc_hd__decap_12
X_226_ _068_ _069_ VGND VGND VPWR VPWR _029_ sky130_fd_sc_hd__nor2_1
XFILLER_0_18_53 VPWR VGND VPWR VGND sky130_ef_sc_hd__decap_12
XFILLER_0_24_6 VPWR VGND VPWR VGND sky130_ef_sc_hd__decap_12
XFILLER_0_0_97 VPWR VGND VPWR VGND sky130_ef_sc_hd__decap_12
XPHY_EDGE_ROW_22_Right_22 VGND VGND VPWR VPWR sky130_fd_sc_hd__decap_3
XFILLER_0_15_65 VGND VGND VPWR VPWR sky130_fd_sc_hd__decap_3
XPHY_EDGE_ROW_13_Right_13 VGND VGND VPWR VPWR sky130_fd_sc_hd__decap_3
XFILLER_0_22_3 VGND VGND VPWR VPWR sky130_fd_sc_hd__fill_1
XFILLER_0_16_141 VPWR VGND VPWR VGND sky130_ef_sc_hd__decap_12
XFILLER_0_22_177 VPWR VGND VPWR VGND sky130_ef_sc_hd__decap_12
XFILLER_0_13_111 VGND VGND VPWR VPWR sky130_fd_sc_hd__fill_1
XFILLER_0_6_85 VPWR VGND VPWR VGND sky130_ef_sc_hd__decap_12
XTAP_TAPCELL_ROW_19_117 VGND VPWR sky130_fd_sc_hd__tapvpwrvgnd_1
X_388_ _033_ VGND VGND VPWR VPWR _008_ sky130_fd_sc_hd__clkbuf_1
XFILLER_0_12_66 VGND VGND VPWR VPWR sky130_fd_sc_hd__fill_1
XFILLER_0_12_33 VGND VGND VPWR VPWR sky130_fd_sc_hd__fill_1
X_457_ clknet_1_1__leaf_CLK100MHZ _023_ VGND VGND VPWR VPWR rf.regs\[5\]\[0\] sky130_fd_sc_hd__dfxtp_1
XTAP_TAPCELL_ROW_24_131 VGND VPWR sky130_fd_sc_hd__tapvpwrvgnd_1
X_311_ _082_ _095_ VGND VGND VPWR VPWR _153_ sky130_fd_sc_hd__or2_1
XTAP_TAPCELL_ROW_16_109 VGND VPWR sky130_fd_sc_hd__tapvpwrvgnd_1
X_242_ _083_ VGND VGND VPWR VPWR _084_ sky130_fd_sc_hd__buf_1
XFILLER_0_5_141 VGND VGND VPWR VPWR sky130_fd_sc_hd__fill_1
XFILLER_0_5_185 VGND VGND VPWR VPWR sky130_fd_sc_hd__fill_2
XFILLER_0_23_43 VGND VGND VPWR VPWR sky130_fd_sc_hd__fill_1
XTAP_TAPCELL_ROW_21_123 VGND VPWR sky130_fd_sc_hd__tapvpwrvgnd_1
XFILLER_0_3_86 VPWR VGND VPWR VGND sky130_ef_sc_hd__decap_12
X_225_ net2 _067_ _065_ VGND VGND VPWR VPWR _069_ sky130_fd_sc_hd__a21oi_1
XFILLER_0_18_65 VPWR VGND VPWR VGND sky130_ef_sc_hd__decap_12
XPHY_EDGE_ROW_9_Left_37 VGND VGND VPWR VPWR sky130_fd_sc_hd__decap_3
XFILLER_0_0_54 VGND VGND VPWR VPWR sky130_fd_sc_hd__fill_2
XFILLER_0_15_3 VGND VGND VPWR VPWR sky130_fd_sc_hd__decap_4
XFILLER_0_22_189 VGND VGND VPWR VPWR sky130_fd_sc_hd__fill_1
XFILLER_0_13_189 VGND VGND VPWR VPWR sky130_fd_sc_hd__fill_1
XFILLER_0_13_167 VGND VGND VPWR VPWR sky130_fd_sc_hd__fill_1
XFILLER_0_6_97 VPWR VGND VPWR VGND sky130_ef_sc_hd__decap_12
XTAP_TAPCELL_ROW_19_118 VGND VPWR sky130_fd_sc_hd__tapvpwrvgnd_1
XTAP_TAPCELL_ROW_27_140 VGND VPWR sky130_fd_sc_hd__tapvpwrvgnd_1
X_387_ rf.regs\[15\]\[0\] _184_ _032_ VGND VGND VPWR VPWR _033_ sky130_fd_sc_hd__mux2_1
X_456_ clknet_1_1__leaf_CLK100MHZ _022_ VGND VGND VPWR VPWR rf.regs\[0\]\[4\] sky130_fd_sc_hd__dfxtp_1
XFILLER_0_6_109 VPWR VGND VPWR VGND sky130_ef_sc_hd__decap_12
XTAP_TAPCELL_ROW_24_132 VGND VPWR sky130_fd_sc_hd__tapvpwrvgnd_1
X_310_ _144_ _151_ VGND VGND VPWR VPWR _152_ sky130_fd_sc_hd__xnor2_2
X_241_ _082_ VGND VGND VPWR VPWR _083_ sky130_fd_sc_hd__dlymetal6s2s_1
X_439_ clknet_1_1__leaf_CLK100MHZ _005_ VGND VGND VPWR VPWR rf.regs\[25\]\[2\] sky130_fd_sc_hd__dfxtp_1
XTAP_TAPCELL_ROW_21_124 VGND VPWR sky130_fd_sc_hd__tapvpwrvgnd_1
XFILLER_0_3_10 VGND VGND VPWR VPWR sky130_fd_sc_hd__fill_2
XFILLER_0_3_98 VGND VGND VPWR VPWR sky130_fd_sc_hd__decap_4
X_224_ _064_ _068_ VGND VGND VPWR VPWR _030_ sky130_fd_sc_hd__xor2_1
XPHY_EDGE_ROW_25_Left_53 VGND VGND VPWR VPWR sky130_fd_sc_hd__decap_3
XFILLER_0_18_77 VGND VGND VPWR VPWR sky130_fd_sc_hd__decap_6
XFILLER_0_20_45 VGND VGND VPWR VPWR sky130_fd_sc_hd__fill_1
XFILLER_0_9_31 VGND VGND VPWR VPWR sky130_fd_sc_hd__fill_1
XPHY_EDGE_ROW_12_Left_40 VGND VGND VPWR VPWR sky130_fd_sc_hd__decap_3
XPHY_EDGE_ROW_7_Right_7 VGND VGND VPWR VPWR sky130_fd_sc_hd__decap_3
XFILLER_0_16_187 VGND VGND VPWR VPWR sky130_fd_sc_hd__decap_3
XFILLER_0_26_99 VGND VGND VPWR VPWR sky130_fd_sc_hd__decap_3
XFILLER_0_6_54 VGND VGND VPWR VPWR sky130_fd_sc_hd__fill_1
XTAP_TAPCELL_ROW_27_141 VGND VPWR sky130_fd_sc_hd__tapvpwrvgnd_1
XFILLER_0_12_79 VGND VGND VPWR VPWR sky130_fd_sc_hd__decap_4
X_386_ _031_ VGND VGND VPWR VPWR _032_ sky130_fd_sc_hd__buf_2
X_455_ clknet_1_0__leaf_CLK100MHZ _021_ VGND VGND VPWR VPWR rf.regs\[0\]\[3\] sky130_fd_sc_hd__dfxtp_1
XFILLER_0_10_105 VPWR VGND VPWR VGND sky130_ef_sc_hd__decap_12
XTAP_TAPCELL_ROW_24_133 VGND VPWR sky130_fd_sc_hd__tapvpwrvgnd_1
X_240_ _081_ VGND VGND VPWR VPWR _082_ sky130_fd_sc_hd__buf_1
X_369_ rf.regs\[25\]\[2\] _157_ _199_ VGND VGND VPWR VPWR _202_ sky130_fd_sc_hd__mux2_1
X_438_ clknet_1_1__leaf_CLK100MHZ _004_ VGND VGND VPWR VPWR rf.regs\[25\]\[1\] sky130_fd_sc_hd__dfxtp_1
XFILLER_0_2_102 VGND VGND VPWR VPWR sky130_fd_sc_hd__fill_1
XFILLER_0_3_55 VGND VGND VPWR VPWR sky130_fd_sc_hd__fill_1
X_223_ net2 _065_ _067_ VGND VGND VPWR VPWR _068_ sky130_fd_sc_hd__and3_1
XFILLER_0_25_111 VGND VGND VPWR VPWR sky130_fd_sc_hd__fill_1
XFILLER_0_15_57 VGND VGND VPWR VPWR sky130_fd_sc_hd__decap_8
XFILLER_0_26_78 VGND VGND VPWR VPWR sky130_fd_sc_hd__decap_6
XFILLER_0_13_169 VGND VGND VPWR VPWR sky130_fd_sc_hd__fill_1
XFILLER_0_8_141 VGND VGND VPWR VPWR sky130_fd_sc_hd__decap_4
XTAP_TAPCELL_ROW_27_142 VGND VPWR sky130_fd_sc_hd__tapvpwrvgnd_1
X_385_ net2 _067_ _101_ VGND VGND VPWR VPWR _031_ sky130_fd_sc_hd__and3_1
X_454_ clknet_1_0__leaf_CLK100MHZ _020_ VGND VGND VPWR VPWR rf.regs\[0\]\[2\] sky130_fd_sc_hd__dfxtp_1
XFILLER_0_10_117 VGND VGND VPWR VPWR sky130_fd_sc_hd__decap_8
XFILLER_0_10_128 VGND VGND VPWR VPWR sky130_fd_sc_hd__decap_3
XFILLER_0_5_177 VGND VGND VPWR VPWR sky130_fd_sc_hd__decap_8
XFILLER_0_23_57 VPWR VGND VPWR VGND sky130_ef_sc_hd__decap_12
X_437_ clknet_1_0__leaf_CLK100MHZ _003_ VGND VGND VPWR VPWR rf.regs\[25\]\[0\] sky130_fd_sc_hd__dfxtp_1
X_368_ _201_ VGND VGND VPWR VPWR _004_ sky130_fd_sc_hd__clkbuf_1
X_299_ _140_ _136_ VGND VGND VPWR VPWR _141_ sky130_fd_sc_hd__nand2_1
X_222_ _066_ VGND VGND VPWR VPWR _067_ sky130_fd_sc_hd__clkbuf_4
XFILLER_0_18_24 VGND VGND VPWR VPWR sky130_fd_sc_hd__decap_4
XTAP_TAPCELL_ROW_8_83 VGND VPWR sky130_fd_sc_hd__tapvpwrvgnd_1
Xclkbuf_1_1__f_CLK100MHZ clknet_0_CLK100MHZ VGND VGND VPWR VPWR clknet_1_1__leaf_CLK100MHZ
+ sky130_fd_sc_hd__clkbuf_16
XFILLER_0_0_57 VPWR VGND VPWR VGND sky130_ef_sc_hd__decap_12
XFILLER_0_0_46 VGND VGND VPWR VPWR sky130_fd_sc_hd__decap_8
XFILLER_0_9_55 VGND VGND VPWR VPWR sky130_fd_sc_hd__fill_1
XFILLER_0_9_99 VGND VGND VPWR VPWR sky130_fd_sc_hd__fill_1
XFILLER_0_19_186 VGND VGND VPWR VPWR sky130_fd_sc_hd__decap_4
XFILLER_0_25_189 VGND VGND VPWR VPWR sky130_fd_sc_hd__fill_1
XFILLER_0_25_156 VGND VGND VPWR VPWR sky130_fd_sc_hd__fill_1
XFILLER_0_16_167 VPWR VGND VPWR VGND sky130_ef_sc_hd__decap_12
XFILLER_0_16_134 VGND VGND VPWR VPWR sky130_fd_sc_hd__decap_6
XFILLER_0_16_101 VPWR VGND VPWR VGND sky130_ef_sc_hd__decap_12
XFILLER_0_26_35 VPWR VGND VPWR VGND sky130_ef_sc_hd__decap_12
XFILLER_0_13_137 VPWR VGND VPWR VGND sky130_ef_sc_hd__decap_12
XFILLER_0_13_3 VGND VGND VPWR VPWR sky130_fd_sc_hd__decap_8
XFILLER_0_8_131 VGND VGND VPWR VPWR sky130_fd_sc_hd__fill_1
XTAP_TAPCELL_ROW_27_143 VGND VPWR sky130_fd_sc_hd__tapvpwrvgnd_1
XFILLER_0_12_15 VGND VGND VPWR VPWR sky130_fd_sc_hd__decap_8
X_453_ clknet_1_0__leaf_CLK100MHZ _019_ VGND VGND VPWR VPWR rf.regs\[0\]\[1\] sky130_fd_sc_hd__dfxtp_1
X_384_ _214_ VGND VGND VPWR VPWR _007_ sky130_fd_sc_hd__buf_1
XFILLER_0_5_167 VGND VGND VPWR VPWR sky130_fd_sc_hd__fill_1
XFILLER_0_2_3 VGND VGND VPWR VPWR sky130_fd_sc_hd__fill_1
X_367_ rf.regs\[25\]\[1\] _138_ _199_ VGND VGND VPWR VPWR _201_ sky130_fd_sc_hd__mux2_1
XFILLER_0_23_69 VPWR VGND VPWR VGND sky130_ef_sc_hd__decap_12
X_298_ _139_ VGND VGND VPWR VPWR _140_ sky130_fd_sc_hd__buf_1
XFILLER_0_2_159 VGND VGND VPWR VPWR sky130_fd_sc_hd__fill_1
XFILLER_0_2_137 VGND VGND VPWR VPWR sky130_fd_sc_hd__decap_3
X_436_ net1 VGND VGND VPWR VPWR _002_ sky130_fd_sc_hd__inv_2
XFILLER_0_3_57 VGND VGND VPWR VPWR sky130_fd_sc_hd__fill_2
X_221_ imem.address\[0\] VGND VGND VPWR VPWR _066_ sky130_fd_sc_hd__clkbuf_4
XTAP_TAPCELL_ROW_8_84 VGND VPWR sky130_fd_sc_hd__tapvpwrvgnd_1
X_419_ _051_ VGND VGND VPWR VPWR _021_ sky130_fd_sc_hd__clkbuf_1
XFILLER_0_0_69 VPWR VGND VPWR VGND sky130_ef_sc_hd__decap_12
XFILLER_0_19_132 VPWR VGND VPWR VGND sky130_ef_sc_hd__decap_12
XFILLER_0_19_121 VGND VGND VPWR VPWR sky130_fd_sc_hd__decap_4
XTAP_TAPCELL_ROW_5_74 VGND VPWR sky130_fd_sc_hd__tapvpwrvgnd_1
XFILLER_0_21_80 VGND VGND VPWR VPWR sky130_fd_sc_hd__decap_4
XFILLER_0_16_179 VGND VGND VPWR VPWR sky130_fd_sc_hd__decap_8
XFILLER_0_16_113 VGND VGND VPWR VPWR sky130_fd_sc_hd__decap_4
XFILLER_0_15_7 VGND VGND VPWR VPWR sky130_fd_sc_hd__fill_1
XPHY_EDGE_ROW_16_Left_44 VGND VGND VPWR VPWR sky130_fd_sc_hd__decap_3
XFILLER_0_13_149 VPWR VGND VPWR VGND sky130_ef_sc_hd__decap_12
XANTENNA_1 _031_ VGND VGND VPWR VPWR sky130_fd_sc_hd__diode_2
XTAP_TAPCELL_ROW_27_144 VGND VPWR sky130_fd_sc_hd__tapvpwrvgnd_1
XFILLER_0_16_91 VGND VGND VPWR VPWR sky130_fd_sc_hd__fill_1
XFILLER_0_12_182 VGND VGND VPWR VPWR sky130_fd_sc_hd__fill_1
X_452_ clknet_1_1__leaf_CLK100MHZ _018_ VGND VGND VPWR VPWR rf.regs\[0\]\[0\] sky130_fd_sc_hd__dfxtp_1
X_383_ rf.regs\[25\]\[4\] _213_ _199_ VGND VGND VPWR VPWR _214_ sky130_fd_sc_hd__mux2_1
Xoutput3 net3 VGND VGND VPWR VPWR seg[0] sky130_fd_sc_hd__buf_1
XFILLER_0_12_27 VGND VGND VPWR VPWR sky130_fd_sc_hd__fill_1
XPHY_EDGE_ROW_1_Left_29 VGND VGND VPWR VPWR sky130_fd_sc_hd__decap_3
XFILLER_0_5_113 VPWR VGND VPWR VGND sky130_ef_sc_hd__decap_12
X_297_ _128_ _134_ VGND VGND VPWR VPWR _139_ sky130_fd_sc_hd__and2_1
X_366_ _200_ VGND VGND VPWR VPWR _003_ sky130_fd_sc_hd__clkbuf_1
X_435_ net1 VGND VGND VPWR VPWR _001_ sky130_fd_sc_hd__inv_2
XFILLER_0_18_15 VGND VGND VPWR VPWR sky130_fd_sc_hd__decap_4
XTAP_TAPCELL_ROW_12_95 VGND VPWR sky130_fd_sc_hd__tapvpwrvgnd_1
X_220_ imem.address\[1\] VGND VGND VPWR VPWR _065_ sky130_fd_sc_hd__clkbuf_4
X_349_ _157_ VGND VGND VPWR VPWR _190_ sky130_fd_sc_hd__inv_2
X_418_ rf.regs\[0\]\[3\] _047_ VGND VGND VPWR VPWR _051_ sky130_fd_sc_hd__and2_1
XTAP_TAPCELL_ROW_8_85 VGND VPWR sky130_fd_sc_hd__tapvpwrvgnd_1
XFILLER_0_20_27 VGND VGND VPWR VPWR sky130_fd_sc_hd__fill_1
XFILLER_0_0_15 VPWR VGND VPWR VGND sky130_ef_sc_hd__decap_12
XPHY_EDGE_ROW_4_Left_32 VGND VGND VPWR VPWR sky130_fd_sc_hd__decap_3
XFILLER_0_19_177 VGND VGND VPWR VPWR sky130_fd_sc_hd__fill_1
XFILLER_0_19_144 VPWR VGND VPWR VGND sky130_ef_sc_hd__decap_12
XFILLER_0_19_111 VGND VGND VPWR VPWR sky130_fd_sc_hd__fill_1
XFILLER_0_9_35 VGND VGND VPWR VPWR sky130_fd_sc_hd__decap_4
XFILLER_0_9_57 VPWR VGND VPWR VGND sky130_ef_sc_hd__decap_12
XFILLER_0_25_169 VPWR VGND VPWR VGND sky130_ef_sc_hd__decap_12
XTAP_TAPCELL_ROW_5_75 VGND VPWR sky130_fd_sc_hd__tapvpwrvgnd_1
XFILLER_0_21_92 VGND VGND VPWR VPWR sky130_fd_sc_hd__fill_1
XFILLER_0_6_58 VPWR VGND VPWR VGND sky130_ef_sc_hd__decap_12
XANTENNA_2 _053_ VGND VGND VPWR VPWR sky130_fd_sc_hd__diode_2
XTAP_TAPCELL_ROW_27_145 VGND VPWR sky130_fd_sc_hd__tapvpwrvgnd_1
X_451_ clknet_1_0__leaf_CLK100MHZ _017_ VGND VGND VPWR VPWR rf.regs\[10\]\[4\] sky130_fd_sc_hd__dfxtp_1
Xoutput4 net4 VGND VGND VPWR VPWR seg[1] sky130_fd_sc_hd__buf_1
X_382_ _211_ _212_ VGND VGND VPWR VPWR _213_ sky130_fd_sc_hd__nor2_1
XTAP_TAPCELL_ROW_2_65 VGND VPWR sky130_fd_sc_hd__tapvpwrvgnd_1
XFILLER_0_5_125 VPWR VGND VPWR VGND sky130_ef_sc_hd__decap_12
XTAP_TAPCELL_ROW_15_104 VGND VPWR sky130_fd_sc_hd__tapvpwrvgnd_1
X_434_ net1 VGND VGND VPWR VPWR _000_ sky130_fd_sc_hd__inv_2
X_365_ rf.regs\[25\]\[0\] _184_ _199_ VGND VGND VPWR VPWR _200_ sky130_fd_sc_hd__mux2_1
X_296_ _112_ _114_ _123_ _137_ VGND VGND VPWR VPWR _138_ sky130_fd_sc_hd__a22o_4
XTAP_TAPCELL_ROW_12_96 VGND VPWR sky130_fd_sc_hd__tapvpwrvgnd_1
XFILLER_0_1_150 VPWR VGND VPWR VGND sky130_ef_sc_hd__decap_12
XPHY_EDGE_ROW_25_Right_25 VGND VGND VPWR VPWR sky130_fd_sc_hd__decap_3
X_417_ _050_ VGND VGND VPWR VPWR _020_ sky130_fd_sc_hd__buf_1
XPHY_EDGE_ROW_16_Right_16 VGND VGND VPWR VPWR sky130_fd_sc_hd__decap_3
X_348_ _188_ VGND VGND VPWR VPWR _189_ sky130_fd_sc_hd__inv_2
X_279_ rf.regs\[25\]\[1\] _120_ _107_ VGND VGND VPWR VPWR _121_ sky130_fd_sc_hd__a21oi_1
XFILLER_0_0_27 VGND VGND VPWR VPWR sky130_fd_sc_hd__fill_1
XFILLER_0_9_69 VPWR VGND VPWR VGND sky130_ef_sc_hd__decap_12
XFILLER_0_10_83 VGND VGND VPWR VPWR sky130_fd_sc_hd__fill_1
XFILLER_0_19_156 VPWR VGND VPWR VGND sky130_ef_sc_hd__decap_12
XTAP_TAPCELL_ROW_5_76 VGND VPWR sky130_fd_sc_hd__tapvpwrvgnd_1
XFILLER_0_22_129 VGND VGND VPWR VPWR sky130_fd_sc_hd__decap_4
XFILLER_0_1_81 VGND VGND VPWR VPWR sky130_fd_sc_hd__decap_8
XPHY_EDGE_ROW_2_Right_2 VGND VGND VPWR VPWR sky130_fd_sc_hd__decap_3
XFILLER_0_26_27 VGND VGND VPWR VPWR sky130_fd_sc_hd__fill_1
XANTENNA_3 _109_ VGND VGND VPWR VPWR sky130_fd_sc_hd__diode_2
XFILLER_0_6_48 VGND VGND VPWR VPWR sky130_fd_sc_hd__decap_6
XFILLER_0_20_7 VPWR VGND VPWR VGND sky130_ef_sc_hd__decap_12
XFILLER_0_8_101 VGND VGND VPWR VPWR sky130_fd_sc_hd__fill_1
XFILLER_0_12_29 VGND VGND VPWR VPWR sky130_fd_sc_hd__decap_4
Xoutput5 net5 VGND VGND VPWR VPWR seg[2] sky130_fd_sc_hd__buf_1
XTAP_TAPCELL_ROW_2_66 VGND VPWR sky130_fd_sc_hd__tapvpwrvgnd_1
X_381_ _210_ _204_ VGND VGND VPWR VPWR _212_ sky130_fd_sc_hd__and2b_1
X_450_ clknet_1_0__leaf_CLK100MHZ _016_ VGND VGND VPWR VPWR rf.regs\[10\]\[3\] sky130_fd_sc_hd__dfxtp_1
XFILLER_0_27_81 VGND VGND VPWR VPWR sky130_fd_sc_hd__decap_3
XTAP_TAPCELL_ROW_18_113 VGND VPWR sky130_fd_sc_hd__tapvpwrvgnd_1
XFILLER_0_5_137 VGND VGND VPWR VPWR sky130_fd_sc_hd__decap_4
XFILLER_0_5_159 VGND VGND VPWR VPWR sky130_fd_sc_hd__decap_8
XTAP_TAPCELL_ROW_15_105 VGND VPWR sky130_fd_sc_hd__tapvpwrvgnd_1
XFILLER_0_7_80 VPWR VGND VPWR VGND sky130_ef_sc_hd__decap_12
X_433_ _059_ VGND VGND VPWR VPWR _027_ sky130_fd_sc_hd__buf_1
XFILLER_0_11_3 VGND VGND VPWR VPWR sky130_fd_sc_hd__decap_8
X_295_ _128_ _135_ _136_ VGND VGND VPWR VPWR _137_ sky130_fd_sc_hd__and3_2
X_364_ _198_ VGND VGND VPWR VPWR _199_ sky130_fd_sc_hd__buf_2
XFILLER_0_2_129 VGND VGND VPWR VPWR sky130_fd_sc_hd__decap_8
XFILLER_0_3_49 VGND VGND VPWR VPWR sky130_fd_sc_hd__fill_1
XFILLER_0_13_94 VGND VGND VPWR VPWR sky130_fd_sc_hd__fill_1
XTAP_TAPCELL_ROW_12_97 VGND VPWR sky130_fd_sc_hd__tapvpwrvgnd_1
XFILLER_0_1_162 VGND VGND VPWR VPWR sky130_fd_sc_hd__decap_6
X_347_ _158_ _187_ VGND VGND VPWR VPWR _188_ sky130_fd_sc_hd__nor2_2
X_278_ _119_ VGND VGND VPWR VPWR _120_ sky130_fd_sc_hd__clkbuf_1
X_416_ rf.regs\[0\]\[2\] _047_ VGND VGND VPWR VPWR _050_ sky130_fd_sc_hd__and2_1
XFILLER_0_0_3 VPWR VGND VPWR VGND sky130_ef_sc_hd__decap_12
XFILLER_0_24_60 VPWR VGND VPWR VGND sky130_ef_sc_hd__decap_12
XFILLER_0_20_29 VPWR VGND VPWR VGND sky130_ef_sc_hd__decap_12
XFILLER_0_4_81 VGND VGND VPWR VPWR sky130_fd_sc_hd__decap_3
XFILLER_0_10_51 VGND VGND VPWR VPWR sky130_fd_sc_hd__decap_8
XFILLER_0_25_138 VPWR VGND VPWR VGND sky130_ef_sc_hd__decap_12
XFILLER_0_25_105 VGND VGND VPWR VPWR sky130_fd_sc_hd__decap_6
XFILLER_0_22_108 VPWR VGND VPWR VGND sky130_ef_sc_hd__decap_12
XFILLER_0_21_185 VGND VGND VPWR VPWR sky130_fd_sc_hd__decap_4
XANTENNA_4 _204_ VGND VGND VPWR VPWR sky130_fd_sc_hd__diode_2
XFILLER_0_8_168 VPWR VGND VPWR VGND sky130_ef_sc_hd__decap_12
X_380_ _204_ _210_ VGND VGND VPWR VPWR _211_ sky130_fd_sc_hd__and2b_1
XTAP_TAPCELL_ROW_2_67 VGND VPWR sky130_fd_sc_hd__tapvpwrvgnd_1
Xoutput6 net6 VGND VGND VPWR VPWR seg[3] sky130_fd_sc_hd__buf_1
XTAP_TAPCELL_ROW_18_114 VGND VPWR sky130_fd_sc_hd__tapvpwrvgnd_1
.ends
